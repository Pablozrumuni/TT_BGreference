* NGSPICE file created from tt_um_chip_ieee_analog.ext - technology: ihp-sg13g2

.subckt tt_um_chip_ieee_analog clk ena rst_n ui_in[0] ui_in[1] ui_in[2] ui_in[3] ui_in[4]
+ ui_in[5] ui_in[6] ui_in[7] uio_in[0] uio_in[1] uio_in[2] uio_in[3] uio_in[4] uio_in[5]
+ uio_in[6] uio_in[7] uio_oe[0] uio_oe[1] uio_oe[2] uio_oe[3] uio_oe[4] uio_oe[5]
+ uio_oe[6] uio_oe[7] uio_out[0] uio_out[1] uio_out[2] uio_out[3] uio_out[4] uio_out[5]
+ uio_out[6] uio_out[7] uo_out[0] uo_out[1] uo_out[2] uo_out[3] uo_out[4] uo_out[5]
+ uo_out[6] uo_out[7] ua[0] ua[1] ua[2] ua[3] ua[4] ua[5] ua[6] ua[7] VDPWR VGND
X0 a_13554_19156# a_12731_21863# VDPWR.t35 VDPWR.t33 sg13_lv_pmos ad=0.17p pd=1.68u as=0.17p ps=1.68u w=0.5u l=1u
X1 a_4462_20340# a_12278_20034# VGND.t0 rppd l=38.65u w=0.71u
X2 ua[2] ua[0] VDPWR.t54 VDPWR.t42 sg13_lv_pmos ad=1.78125p pd=9.755u as=1.78125p ps=9.755u w=9.375u l=2.08u
X3 VDPWR.t77 VGND.t34 cap_cmim l=5u w=5u
X4 VDPWR.t12 ua[2] a_5691_14643# VDPWR.t11 sg13_lv_pmos ad=0.35625p pd=2.255u as=0.35625p ps=2.255u w=1.875u l=5u
X5 a_4461_19770# a_4461_19770# VGND.t52 VGND.t55 sg13_lv_nmos ad=0.49875p pd=3.005u as=0.49875p ps=3.005u w=2.625u l=5u
X6 ua[2] ua[0] VDPWR.t56 VDPWR.t45 sg13_lv_pmos ad=1.78125p pd=9.755u as=1.78125p ps=9.755u w=9.375u l=2.08u
X7 VDPWR.t76 VDPWR.t75 a_17330_18472# VDPWR.t0 sg13_lv_pmos ad=1.2376p pd=7.96u as=1.2376p ps=7.96u w=3.64u l=3.7u
X8 ua[0] ua[0] VDPWR.t47 VDPWR.t48 sg13_lv_pmos ad=1.78125p pd=9.755u as=1.78125p ps=9.755u w=9.375u l=2.08u
X9 a_17330_18472# ua[2] cap_cmim l=22.29u w=22.29u
X10 VDPWR.t56 ua[0] ua[2] VDPWR.t43 sg13_lv_pmos ad=1.78125p pd=9.755u as=1.78125p ps=9.755u w=9.375u l=2.08u
X11 a_15380_18436# a_5691_14643# a_16457_19785# VDPWR.t0 sg13_lv_pmos ad=1.2376p pd=7.96u as=1.2376p ps=7.96u w=3.64u l=3.7u
X12 ua[2] a_17330_18472# VGND.t45 VGND.t41 sg13_lv_nmos ad=1.368p pd=7.58u as=2.448p ps=15.08u w=7.2u l=9.75u
X13 VDPWR.t58 ua[0] ua[2] VDPWR.t46 sg13_lv_pmos ad=1.78125p pd=9.755u as=1.78125p ps=9.755u w=9.375u l=2.08u
X14 ua[1] ua[2] VDPWR.t26 VDPWR.t5 sg13_lv_pmos ad=0.38p pd=2.38u as=0.38p ps=2.38u w=2u l=5u
X15 a_4462_20340# a_12278_20646# VGND.t0 rppd l=38.65u w=0.71u
X16 VGND.t4 a_5691_14086# a_5691_14643# VGND.t5 sg13_lv_nmos ad=0.33915p pd=2.165u as=0.33915p ps=2.165u w=1.785u l=5u
X17 VDPWR.t78 VGND.t23 cap_cmim l=5u w=5u
X18 VDPWR.t50 ua[0] ua[0] VDPWR.t49 sg13_lv_pmos ad=3.1875p pd=19.43u as=1.78125p ps=9.755u w=9.375u l=2.08u
X19 VDPWR.t72 VDPWR.t71 a_15380_18436# VDPWR.t0 sg13_lv_pmos ad=1.2376p pd=7.96u as=1.2376p ps=7.96u w=3.64u l=3.7u
X20 VDPWR.t77 VGND.t36 cap_cmim l=5u w=5u
X21 ua[1] ua[2] VDPWR.t28 VDPWR.t13 sg13_lv_pmos ad=0.38p pd=2.38u as=0.38p ps=2.38u w=2u l=5u
X22 VGND.t59 a_12277_16894# VGND.t8 rppd l=38.65u w=3u
X23 VDPWR.t32 ua[2] ua[1] VDPWR.t17 sg13_lv_pmos ad=0.68p pd=4.68u as=0.38p ps=2.38u w=2u l=5u
X24 a_5691_14643# ua[2] VDPWR.t9 VDPWR.t5 sg13_lv_pmos ad=0.35625p pd=2.255u as=0.35625p ps=2.255u w=1.875u l=5u
X25 a_5691_14643# a_5691_14086# VGND.t7 VGND.t6 sg13_lv_nmos ad=0.33915p pd=2.165u as=0.6069p ps=4.25u w=1.785u l=5u
X26 a_4461_18186# a_5691_14086# VGND.t8 rppd l=38.65u w=0.5u
X27 a_5691_14643# ua[2] VDPWR.t12 VDPWR.t13 sg13_lv_pmos ad=0.35625p pd=2.255u as=0.35625p ps=2.255u w=1.875u l=5u
X28 VDPWR.t79 VGND.t23 cap_cmim l=5u w=5u
X29 a_4461_18186# a_12277_17922# VGND.t8 rppd l=38.65u w=0.5u
X30 VDPWR.t6 ua[2] a_5691_14086# VDPWR.t8 sg13_lv_pmos ad=0.35625p pd=2.255u as=0.35625p ps=2.255u w=1.875u l=5u
X31 ua[2] ua[0] VDPWR.t58 VDPWR.t48 sg13_lv_pmos ad=1.78125p pd=9.755u as=1.78125p ps=9.755u w=9.375u l=2.08u
X32 VDPWR.t18 ua[2] a_5691_14643# VDPWR.t17 sg13_lv_pmos ad=0.6375p pd=4.43u as=0.35625p ps=2.255u w=1.875u l=5u
X33 VDPWR.t52 ua[0] a_16457_19785# VDPWR.t51 sg13_lv_pmos ad=1.802p pd=11.28u as=1.802p ps=11.28u w=5.3u l=1.95u
X34 a_4461_17658# a_12277_17922# VGND.t8 rppd l=38.65u w=0.5u
X35 VDPWR.t2 a_13554_19156# a_5691_14643# VDPWR.t1 sg13_lv_pmos ad=0.104p pd=1.34u as=0.104p ps=1.34u w=0.2u l=4u
X36 VGND.t52 a_4461_19770# a_4461_19770# VGND.t51 sg13_lv_nmos ad=0.49875p pd=3.005u as=0.49875p ps=3.005u w=2.625u l=5u
X37 a_15380_18436# a_15380_18436# VGND.t12 VGND.t11 sg13_lv_nmos ad=0.2448p pd=2.12u as=0.2448p ps=2.12u w=0.72u l=9.75u
X38 a_4461_19770# a_4461_19770# VGND.t47 VGND.t46 sg13_lv_nmos ad=0.49875p pd=3.005u as=0.8925p ps=5.93u w=2.625u l=5u
X39 a_4461_17658# a_12277_16894# VGND.t8 rppd l=38.65u w=0.5u
X40 a_5691_14086# ua[2] VDPWR.t22 VDPWR.t16 sg13_lv_pmos ad=0.35625p pd=2.255u as=0.35625p ps=2.255u w=1.875u l=5u
X41 VGND.t52 a_4461_19770# a_4461_19770# VGND.t54 sg13_lv_nmos ad=0.49875p pd=3.005u as=0.49875p ps=3.005u w=2.625u l=5u
X42 VDPWR.t60 ua[0] ua[2] VDPWR.t49 sg13_lv_pmos ad=3.1875p pd=19.43u as=1.78125p ps=9.755u w=9.375u l=2.08u
X43 VDPWR.t34 a_12731_21863# a_13554_19156# VDPWR.t33 sg13_lv_pmos ad=0.17p pd=1.68u as=0.17p ps=1.68u w=0.5u l=1u
X44 a_17330_18472# a_5691_14086# a_16457_19785# VDPWR.t0 sg13_lv_pmos ad=1.2376p pd=7.96u as=1.2376p ps=7.96u w=3.64u l=3.7u
X45 a_4462_21565# a_12278_21258# VGND.t0 rppd l=38.65u w=0.71u
X46 a_16457_19785# VDPWR.t61 VDPWR.t62 VDPWR.t0 sg13_lv_pmos ad=1.2376p pd=7.96u as=1.2376p ps=7.96u w=3.64u l=3.7u
X47 a_5691_14086# ua[2] VDPWR.t4 VDPWR.t3 sg13_lv_pmos ad=0.35625p pd=2.255u as=0.6375p ps=4.43u w=1.875u l=5u
X48 a_4461_19242# a_12277_19506# VGND.t8 rppd l=38.65u w=0.5u
X49 ua[2] a_17330_18472# VGND.t43 VGND.t41 sg13_lv_nmos ad=1.368p pd=7.58u as=1.368p ps=7.58u w=7.2u l=9.75u
X50 ua[0] ua[0] VDPWR.t39 VDPWR.t38 sg13_lv_pmos ad=1.78125p pd=9.755u as=3.1875p ps=19.43u w=9.375u l=2.08u
X51 a_4462_20952# a_12278_20646# VGND.t0 rppd l=38.65u w=0.71u
X52 VDPWR.t78 VGND.t19 cap_cmim l=5u w=5u
X53 VDPWR.t26 ua[2] ua[1] VDPWR.t8 sg13_lv_pmos ad=0.38p pd=2.38u as=0.38p ps=2.38u w=2u l=5u
X54 VDPWR.t22 ua[2] a_5691_14086# VDPWR.t14 sg13_lv_pmos ad=0.35625p pd=2.255u as=0.35625p ps=2.255u w=1.875u l=5u
X55 VDPWR.t78 VGND.t21 cap_cmim l=5u w=5u
X56 a_16457_19785# VDPWR.t65 VDPWR.t66 VDPWR.t0 sg13_lv_pmos ad=1.2376p pd=7.96u as=1.2376p ps=7.96u w=3.64u l=3.7u
X57 a_12731_21863# a_12731_21863# VDPWR.t37 VDPWR.t33 sg13_lv_pmos ad=0.17p pd=1.68u as=0.17p ps=1.68u w=0.5u l=1u
X58 ua[1] a_12278_20034# VGND.t0 rppd l=38.65u w=0.71u
X59 VDPWR.t41 ua[0] ua[0] VDPWR.t40 sg13_lv_pmos ad=1.78125p pd=9.755u as=1.78125p ps=9.755u w=9.375u l=2.08u
X60 VDPWR.t9 ua[2] a_5691_14643# VDPWR.t8 sg13_lv_pmos ad=0.35625p pd=2.255u as=0.35625p ps=2.255u w=1.875u l=5u
X61 a_17330_18472# a_5691_14086# a_16457_19785# VDPWR.t0 sg13_lv_pmos ad=1.2376p pd=7.96u as=1.2376p ps=7.96u w=3.64u l=3.7u
X62 ua[1] ua[2] VDPWR.t30 VDPWR.t16 sg13_lv_pmos ad=0.38p pd=2.38u as=0.38p ps=2.38u w=2u l=5u
X63 a_4461_19770# a_12277_19506# VGND.t58 rppd l=38.65u w=0.5u
X64 a_13554_19156# VGND.t9 cap_cmim l=18.2u w=18.2u
X65 VDPWR.t79 VGND.t19 cap_cmim l=5u w=5u
X66 VDPWR.t79 VGND.t21 cap_cmim l=5u w=5u
X67 VDPWR.t20 ua[2] a_5691_14086# VDPWR.t11 sg13_lv_pmos ad=0.35625p pd=2.255u as=0.35625p ps=2.255u w=1.875u l=5u
X68 a_12731_21863# a_5691_14643# VGND.t16 VGND.t15 sg13_lv_nmos ad=0.1005p pd=1.34u as=0.1005p ps=1.34u w=0.15u l=10u
X69 a_4462_20952# a_12278_21258# VGND.t0 rppd l=38.65u w=0.71u
X70 VDPWR.t68 VDPWR.t67 a_15380_18436# VDPWR.t0 sg13_lv_pmos ad=1.2376p pd=7.96u as=1.2376p ps=7.96u w=3.64u l=3.7u
X71 VDPWR.t78 VGND.t17 cap_cmim l=5u w=5u
X72 ua[1] ua[2] VDPWR.t25 VDPWR.t3 sg13_lv_pmos ad=0.38p pd=2.38u as=0.68p ps=4.68u w=2u l=5u
X73 a_5691_14643# ua[2] VDPWR.t15 VDPWR.t16 sg13_lv_pmos ad=0.35625p pd=2.255u as=0.35625p ps=2.255u w=1.875u l=5u
X74 VDPWR.t78 VGND.t25 cap_cmim l=5u w=5u
X75 VDPWR.t77 VGND.t25 cap_cmim l=5u w=5u
X76 ua[2] ua[0] VDPWR.t53 VDPWR.t38 sg13_lv_pmos ad=1.78125p pd=9.755u as=3.1875p ps=19.43u w=9.375u l=2.08u
X77 a_4461_19770# a_4461_19770# VGND.t49 VGND.t50 sg13_lv_nmos ad=0.49875p pd=3.005u as=0.49875p ps=3.005u w=2.625u l=5u
X78 a_5691_14643# a_5691_14086# VGND.t4 VGND.t2 sg13_lv_nmos ad=0.33915p pd=2.165u as=0.33915p ps=2.165u w=1.785u l=5u
X79 a_17330_18472# a_15380_18436# VGND.t14 VGND.t13 sg13_lv_nmos ad=0.2448p pd=2.12u as=0.2448p ps=2.12u w=0.72u l=9.75u
X80 a_4461_18714# a_12277_18978# VGND.t8 rppd l=38.65u w=0.5u
X81 a_16457_19785# VDPWR.t69 VDPWR.t70 VDPWR.t0 sg13_lv_pmos ad=1.2376p pd=7.96u as=1.2376p ps=7.96u w=3.64u l=3.7u
X82 VDPWR.t77 VGND.t38 cap_cmim l=5u w=5u
X83 ua[0] ua[0] VDPWR.t41 VDPWR.t42 sg13_lv_pmos ad=1.78125p pd=9.755u as=1.78125p ps=9.755u w=9.375u l=2.08u
X84 a_4461_19242# a_12277_18978# VGND.t8 rppd l=38.65u w=0.5u
X85 VDPWR.t36 a_12731_21863# a_12731_21863# VDPWR.t33 sg13_lv_pmos ad=0.17p pd=1.68u as=0.17p ps=1.68u w=0.5u l=1u
X86 ua[0] ua[0] VDPWR.t44 VDPWR.t45 sg13_lv_pmos ad=1.78125p pd=9.755u as=1.78125p ps=9.755u w=9.375u l=2.08u
X87 VDPWR.t30 ua[2] ua[1] VDPWR.t14 sg13_lv_pmos ad=0.38p pd=2.38u as=0.38p ps=2.38u w=2u l=5u
X88 a_5691_14643# ua[2] VDPWR.t7 VDPWR.t3 sg13_lv_pmos ad=0.35625p pd=2.255u as=0.6375p ps=4.43u w=1.875u l=5u
X89 VDPWR.t64 VDPWR.t63 a_17330_18472# VDPWR.t0 sg13_lv_pmos ad=1.2376p pd=7.96u as=1.2376p ps=7.96u w=3.64u l=3.7u
X90 VDPWR.t79 VGND.t17 cap_cmim l=5u w=5u
X91 VDPWR.t54 ua[0] ua[2] VDPWR.t40 sg13_lv_pmos ad=1.78125p pd=9.755u as=1.78125p ps=9.755u w=9.375u l=2.08u
X92 a_4462_21565# VGND.t1 VGND.t0 rppd l=38.65u w=0.71u
X93 a_5691_14086# ua[2] VDPWR.t6 VDPWR.t5 sg13_lv_pmos ad=0.35625p pd=2.255u as=0.35625p ps=2.255u w=1.875u l=5u
X94 VGND.t57 a_4461_19770# a_4461_19770# VGND.t56 sg13_lv_nmos ad=0.8925p pd=5.93u as=0.49875p ps=3.005u w=2.625u l=5u
X95 VGND.t43 a_17330_18472# ua[2] VGND.t41 sg13_lv_nmos ad=1.368p pd=7.58u as=1.368p ps=7.58u w=7.2u l=9.75u
X96 VGND.t42 a_17330_18472# ua[2] VGND.t41 sg13_lv_nmos ad=2.448p pd=15.08u as=1.368p ps=7.58u w=7.2u l=9.75u
X97 VDPWR.t79 VGND.t25 cap_cmim l=5u w=5u
X98 VDPWR.t44 ua[0] ua[0] VDPWR.t43 sg13_lv_pmos ad=1.78125p pd=9.755u as=1.78125p ps=9.755u w=9.375u l=2.08u
X99 VDPWR.t47 ua[0] ua[0] VDPWR.t46 sg13_lv_pmos ad=1.78125p pd=9.755u as=1.78125p ps=9.755u w=9.375u l=2.08u
X100 a_4461_18714# a_5691_14086# VGND.t8 rppd l=38.65u w=0.5u
X101 a_4461_19770# a_4461_19770# VGND.t52 VGND.t53 sg13_lv_nmos ad=0.49875p pd=3.005u as=0.49875p ps=3.005u w=2.625u l=5u
X102 a_5691_14086# ua[2] VDPWR.t20 VDPWR.t13 sg13_lv_pmos ad=0.35625p pd=2.255u as=0.35625p ps=2.255u w=1.875u l=5u
X103 a_16457_19785# VDPWR.t73 VDPWR.t74 VDPWR.t0 sg13_lv_pmos ad=1.2376p pd=7.96u as=1.2376p ps=7.96u w=3.64u l=3.7u
X104 VDPWR.t15 ua[2] a_5691_14643# VDPWR.t14 sg13_lv_pmos ad=0.35625p pd=2.255u as=0.35625p ps=2.255u w=1.875u l=5u
X105 VGND.t3 a_5691_14086# a_5691_14643# VGND.t2 sg13_lv_nmos ad=0.6069p pd=4.25u as=0.33915p ps=2.165u w=1.785u l=5u
X106 VDPWR.t28 ua[2] ua[1] VDPWR.t11 sg13_lv_pmos ad=0.38p pd=2.38u as=0.38p ps=2.38u w=2u l=5u
X107 VGND.t49 a_4461_19770# a_4461_19770# VGND.t48 sg13_lv_nmos ad=0.49875p pd=3.005u as=0.49875p ps=3.005u w=2.625u l=5u
X108 VDPWR.t24 ua[2] a_5691_14086# VDPWR.t17 sg13_lv_pmos ad=0.6375p pd=4.43u as=0.35625p ps=2.255u w=1.875u l=5u
X109 a_15380_18436# a_5691_14643# a_16457_19785# VDPWR.t0 sg13_lv_pmos ad=1.2376p pd=7.96u as=1.2376p ps=7.96u w=3.64u l=3.7u
X110 VDPWR.t77 VGND.t32 cap_cmim l=5u w=5u
R0 VDPWR.n1428 VDPWR.n1427 18.6678
R1 VDPWR.n1439 VDPWR.n546 18.6678
R2 VDPWR.n1441 VDPWR.n545 18.6678
R3 VDPWR.n1420 VDPWR.n1093 18.6678
R4 VDPWR.n1419 VDPWR.n1094 18.6678
R5 VDPWR.n1341 VDPWR.n1332 18.6678
R6 VDPWR.n1413 VDPWR.n1333 18.6678
R7 VDPWR.n1411 VDPWR.n1345 18.6678
R8 VDPWR.n1347 VDPWR.n1346 18.6678
R9 VDPWR.n1406 VDPWR.n1349 18.6678
R10 VDPWR.n1359 VDPWR.n1352 18.6678
R11 VDPWR.n1399 VDPWR.n1363 18.6678
R12 VDPWR.n1397 VDPWR.n1364 18.6678
R13 VDPWR.n1370 VDPWR.n1369 18.6678
R14 VDPWR.n1385 VDPWR.n1371 18.6678
R15 VDPWR.n1383 VDPWR.n1381 18.6678
R16 VDPWR.n1378 VDPWR.n549 18.6678
R17 VDPWR.n1433 VDPWR.n1432 18.6678
R18 VDPWR.n1423 VDPWR.n1080 18.6678
R19 VDPWR.n1422 VDPWR.n1081 18.6678
R20 VDPWR.n1421 VDPWR.n1082 18.6678
R21 VDPWR.n1426 VDPWR.n1013 18.6678
R22 VDPWR.n1425 VDPWR.n1014 18.6678
R23 VDPWR.n1424 VDPWR.n1079 18.6678
R24 VDPWR.n1430 VDPWR.n555 17.0005
R25 VDPWR.n1430 VDPWR.n556 17.0005
R26 VDPWR.n1430 VDPWR.n557 17.0005
R27 VDPWR.n1430 VDPWR.n558 17.0005
R28 VDPWR.n1430 VDPWR.n559 17.0005
R29 VDPWR.n1430 VDPWR.n560 17.0005
R30 VDPWR.n1430 VDPWR.n561 17.0005
R31 VDPWR.n1430 VDPWR.n562 17.0005
R32 VDPWR.n1430 VDPWR.n563 17.0005
R33 VDPWR.n1430 VDPWR.n564 17.0005
R34 VDPWR.n1430 VDPWR.n1007 17.0005
R35 VDPWR.n1430 VDPWR.n1006 17.0005
R36 VDPWR.n1430 VDPWR.n1005 17.0005
R37 VDPWR.n1430 VDPWR.n1004 17.0005
R38 VDPWR.n1430 VDPWR.n1003 17.0005
R39 VDPWR.n1430 VDPWR.n1002 17.0005
R40 VDPWR.n1430 VDPWR.n1001 17.0005
R41 VDPWR.n1430 VDPWR.n1000 17.0005
R42 VDPWR.t52 VDPWR.n1037 17.0005
R43 VDPWR.n1051 VDPWR.t52 17.0005
R44 VDPWR.t52 VDPWR.n1044 17.0005
R45 VDPWR.t52 VDPWR.n1043 17.0005
R46 VDPWR.t52 VDPWR.n1045 17.0005
R47 VDPWR.t52 VDPWR.n1042 17.0005
R48 VDPWR.t52 VDPWR.n1046 17.0005
R49 VDPWR.t52 VDPWR.n1041 17.0005
R50 VDPWR.t52 VDPWR.n1047 17.0005
R51 VDPWR.t52 VDPWR.n1040 17.0005
R52 VDPWR.t52 VDPWR.n1048 17.0005
R53 VDPWR.t52 VDPWR.n1039 17.0005
R54 VDPWR.t52 VDPWR.n1049 17.0005
R55 VDPWR.t52 VDPWR.n1038 17.0005
R56 VDPWR.t52 VDPWR.n1050 17.0005
R57 VDPWR.n1430 VDPWR.n632 17.0005
R58 VDPWR.n1430 VDPWR.n631 17.0005
R59 VDPWR.n1430 VDPWR.n630 17.0005
R60 VDPWR.n1430 VDPWR.n629 17.0005
R61 VDPWR.n1430 VDPWR.n628 17.0005
R62 VDPWR.n1430 VDPWR.n627 17.0005
R63 VDPWR.n1430 VDPWR.n625 17.0005
R64 VDPWR.n1430 VDPWR.n624 17.0005
R65 VDPWR.n1430 VDPWR.n607 17.0005
R66 VDPWR.n1430 VDPWR.n605 17.0005
R67 VDPWR.n1430 VDPWR.n604 17.0005
R68 VDPWR.n1430 VDPWR.n603 17.0005
R69 VDPWR.n1430 VDPWR.n601 17.0005
R70 VDPWR.n1430 VDPWR.n600 17.0005
R71 VDPWR.n1430 VDPWR.n588 17.0005
R72 VDPWR.n1430 VDPWR.n589 17.0005
R73 VDPWR.n1430 VDPWR.n590 17.0005
R74 VDPWR.n1430 VDPWR.n591 17.0005
R75 VDPWR.n1430 VDPWR.n592 17.0005
R76 VDPWR.n1430 VDPWR.n593 17.0005
R77 VDPWR.n1430 VDPWR.n594 17.0005
R78 VDPWR.n1430 VDPWR.n595 17.0005
R79 VDPWR.n1431 VDPWR.n1430 17.0005
R80 VDPWR.n1430 VDPWR.n587 17.0005
R81 VDPWR.n1430 VDPWR.n576 17.0005
R82 VDPWR.n1430 VDPWR.n579 17.0005
R83 VDPWR.n1430 VDPWR.n580 17.0005
R84 VDPWR.n1430 VDPWR.n581 17.0005
R85 VDPWR.n1430 VDPWR.n582 17.0005
R86 VDPWR.n1430 VDPWR.n583 17.0005
R87 VDPWR.n1430 VDPWR.n584 17.0005
R88 VDPWR.n1430 VDPWR.n585 17.0005
R89 VDPWR.n1430 VDPWR.n586 17.0005
R90 VDPWR.n1430 VDPWR.n565 17.0005
R91 VDPWR.n1430 VDPWR.n567 17.0005
R92 VDPWR.n1430 VDPWR.n568 17.0005
R93 VDPWR.n1430 VDPWR.n569 17.0005
R94 VDPWR.n1430 VDPWR.n570 17.0005
R95 VDPWR.n1430 VDPWR.n571 17.0005
R96 VDPWR.n1430 VDPWR.n572 17.0005
R97 VDPWR.n1430 VDPWR.n573 17.0005
R98 VDPWR.n1430 VDPWR.n574 17.0005
R99 VDPWR.n1430 VDPWR.t66 17.0005
R100 VDPWR.n922 VDPWR.n742 17.0005
R101 VDPWR.t50 VDPWR.n769 17.0005
R102 VDPWR.t50 VDPWR.n782 17.0005
R103 VDPWR.t50 VDPWR.n781 17.0005
R104 VDPWR.t50 VDPWR.n780 17.0005
R105 VDPWR.t50 VDPWR.n779 17.0005
R106 VDPWR.t50 VDPWR.n778 17.0005
R107 VDPWR.t50 VDPWR.n777 17.0005
R108 VDPWR.t50 VDPWR.n776 17.0005
R109 VDPWR.t50 VDPWR.n775 17.0005
R110 VDPWR.t50 VDPWR.n774 17.0005
R111 VDPWR.t50 VDPWR.n773 17.0005
R112 VDPWR.t50 VDPWR.n772 17.0005
R113 VDPWR.t50 VDPWR.n771 17.0005
R114 VDPWR.t50 VDPWR.n770 17.0005
R115 VDPWR.t50 VDPWR.n789 17.0005
R116 VDPWR.t50 VDPWR.n788 17.0005
R117 VDPWR.t50 VDPWR.n787 17.0005
R118 VDPWR.t50 VDPWR.n786 17.0005
R119 VDPWR.t50 VDPWR.n785 17.0005
R120 VDPWR.t50 VDPWR.n784 17.0005
R121 VDPWR.t50 VDPWR.n783 17.0005
R122 VDPWR.n992 VDPWR.n664 17.0005
R123 VDPWR.n687 VDPWR.n685 17.0005
R124 VDPWR.t60 VDPWR.n698 17.0005
R125 VDPWR.t60 VDPWR.n697 17.0005
R126 VDPWR.t60 VDPWR.n695 17.0005
R127 VDPWR.t60 VDPWR.n694 17.0005
R128 VDPWR.t60 VDPWR.n693 17.0005
R129 VDPWR.t60 VDPWR.n691 17.0005
R130 VDPWR.t60 VDPWR.n690 17.0005
R131 VDPWR.t60 VDPWR.n707 17.0005
R132 VDPWR.t60 VDPWR.n705 17.0005
R133 VDPWR.t60 VDPWR.n710 17.0005
R134 VDPWR.t60 VDPWR.n704 17.0005
R135 VDPWR.t60 VDPWR.n713 17.0005
R136 VDPWR.t60 VDPWR.n703 17.0005
R137 VDPWR.t60 VDPWR.n716 17.0005
R138 VDPWR.t60 VDPWR.n702 17.0005
R139 VDPWR.t60 VDPWR.n719 17.0005
R140 VDPWR.t60 VDPWR.n701 17.0005
R141 VDPWR.t60 VDPWR.n722 17.0005
R142 VDPWR.t60 VDPWR.n700 17.0005
R143 VDPWR.t60 VDPWR.n725 17.0005
R144 VDPWR.t60 VDPWR.n699 17.0005
R145 VDPWR.t60 VDPWR.n988 17.0005
R146 VDPWR.t53 VDPWR.n947 17.0005
R147 VDPWR.t53 VDPWR.n967 17.0005
R148 VDPWR.t53 VDPWR.n938 17.0005
R149 VDPWR.t53 VDPWR.n965 17.0005
R150 VDPWR.t53 VDPWR.n939 17.0005
R151 VDPWR.t53 VDPWR.n962 17.0005
R152 VDPWR.t53 VDPWR.n940 17.0005
R153 VDPWR.t53 VDPWR.n959 17.0005
R154 VDPWR.t53 VDPWR.n941 17.0005
R155 VDPWR.t53 VDPWR.n956 17.0005
R156 VDPWR.t53 VDPWR.n942 17.0005
R157 VDPWR.t53 VDPWR.n953 17.0005
R158 VDPWR.t53 VDPWR.n943 17.0005
R159 VDPWR.t53 VDPWR.n950 17.0005
R160 VDPWR.t53 VDPWR.n944 17.0005
R161 VDPWR.n974 VDPWR.t53 17.0005
R162 VDPWR.t53 VDPWR.n973 17.0005
R163 VDPWR.t53 VDPWR.n933 17.0005
R164 VDPWR.t53 VDPWR.n971 17.0005
R165 VDPWR.t53 VDPWR.n934 17.0005
R166 VDPWR.t53 VDPWR.n969 17.0005
R167 VDPWR.t53 VDPWR.n937 17.0005
R168 VDPWR.n928 VDPWR.n927 17.0005
R169 VDPWR.n742 VDPWR.n739 17.0005
R170 VDPWR.t39 VDPWR.n767 17.0005
R171 VDPWR.t39 VDPWR.n814 17.0005
R172 VDPWR.t39 VDPWR.n768 17.0005
R173 VDPWR.t39 VDPWR.n811 17.0005
R174 VDPWR.t39 VDPWR.n798 17.0005
R175 VDPWR.t39 VDPWR.n808 17.0005
R176 VDPWR.t39 VDPWR.n799 17.0005
R177 VDPWR.t39 VDPWR.n805 17.0005
R178 VDPWR.n818 VDPWR.t39 17.0005
R179 VDPWR.t39 VDPWR.n744 17.0005
R180 VDPWR.t39 VDPWR.n746 17.0005
R181 VDPWR.t39 VDPWR.n748 17.0005
R182 VDPWR.t39 VDPWR.n750 17.0005
R183 VDPWR.t39 VDPWR.n752 17.0005
R184 VDPWR.t39 VDPWR.n754 17.0005
R185 VDPWR.t39 VDPWR.n756 17.0005
R186 VDPWR.t39 VDPWR.n758 17.0005
R187 VDPWR.t39 VDPWR.n760 17.0005
R188 VDPWR.t39 VDPWR.n762 17.0005
R189 VDPWR.t39 VDPWR.n764 17.0005
R190 VDPWR.t39 VDPWR.n766 17.0005
R191 VDPWR.t39 VDPWR.n817 17.0005
R192 VDPWR.t18 VDPWR.n464 17.0005
R193 VDPWR.n467 VDPWR.t18 17.0005
R194 VDPWR.t18 VDPWR.n463 17.0005
R195 VDPWR.t18 VDPWR.n465 17.0005
R196 VDPWR.t18 VDPWR.n466 17.0005
R197 VDPWR.t24 VDPWR.n471 17.0005
R198 VDPWR.t24 VDPWR.n472 17.0005
R199 VDPWR.n474 VDPWR.t24 17.0005
R200 VDPWR.t24 VDPWR.n470 17.0005
R201 VDPWR.t24 VDPWR.n473 17.0005
R202 VDPWR.t32 VDPWR.n479 17.0005
R203 VDPWR.n484 VDPWR.t32 17.0005
R204 VDPWR.t32 VDPWR.n481 17.0005
R205 VDPWR.t32 VDPWR.n482 17.0005
R206 VDPWR.t32 VDPWR.n480 17.0005
R207 VDPWR.t32 VDPWR.n483 17.0005
R208 VDPWR.n322 VDPWR.n286 17.0005
R209 VDPWR.n330 VDPWR.n284 17.0005
R210 VDPWR.t25 VDPWR.n299 17.0005
R211 VDPWR.n301 VDPWR.t25 17.0005
R212 VDPWR.t25 VDPWR.n296 17.0005
R213 VDPWR.t25 VDPWR.n297 17.0005
R214 VDPWR.t25 VDPWR.n298 17.0005
R215 VDPWR.t25 VDPWR.n300 17.0005
R216 VDPWR.t4 VDPWR.n309 17.0005
R217 VDPWR.n311 VDPWR.t4 17.0005
R218 VDPWR.t4 VDPWR.n307 17.0005
R219 VDPWR.t4 VDPWR.n308 17.0005
R220 VDPWR.t4 VDPWR.n310 17.0005
R221 VDPWR.t7 VDPWR.n319 17.0005
R222 VDPWR.n321 VDPWR.t7 17.0005
R223 VDPWR.t7 VDPWR.n317 17.0005
R224 VDPWR.t7 VDPWR.n318 17.0005
R225 VDPWR.t7 VDPWR.n320 17.0005
R226 VDPWR.t67 VDPWR.n1091 15.0005
R227 VDPWR.t67 VDPWR.n1083 15.0005
R228 VDPWR.t67 VDPWR.n1090 15.0005
R229 VDPWR.t67 VDPWR.n1084 15.0005
R230 VDPWR.t67 VDPWR.n1089 15.0005
R231 VDPWR.t67 VDPWR.n1085 15.0005
R232 VDPWR.t67 VDPWR.n1088 15.0005
R233 VDPWR.t67 VDPWR.n1086 15.0005
R234 VDPWR.t67 VDPWR.n1087 15.0005
R235 VDPWR.n1092 VDPWR.t67 15.0005
R236 VDPWR.t75 VDPWR.n1064 15.0005
R237 VDPWR.n1065 VDPWR.t75 15.0005
R238 VDPWR.t75 VDPWR.n1063 15.0005
R239 VDPWR.t75 VDPWR.n1055 15.0005
R240 VDPWR.t75 VDPWR.n1062 15.0005
R241 VDPWR.t75 VDPWR.n1056 15.0005
R242 VDPWR.t75 VDPWR.n1059 15.0005
R243 VDPWR.t75 VDPWR.n1057 15.0005
R244 VDPWR.n615 VDPWR.t69 15.0005
R245 VDPWR.t69 VDPWR.n608 15.0005
R246 VDPWR.t69 VDPWR.n614 15.0005
R247 VDPWR.t69 VDPWR.n609 15.0005
R248 VDPWR.t69 VDPWR.n613 15.0005
R249 VDPWR.t69 VDPWR.n610 15.0005
R250 VDPWR.t69 VDPWR.n612 15.0005
R251 VDPWR.t69 VDPWR.n611 15.0005
R252 VDPWR.t61 VDPWR.n550 15.0005
R253 VDPWR.t61 VDPWR.n1372 15.0005
R254 VDPWR.t61 VDPWR.n1379 15.0005
R255 VDPWR.t61 VDPWR.n1377 15.0005
R256 VDPWR.n1380 VDPWR.t61 15.0005
R257 VDPWR.t61 VDPWR.n1376 15.0005
R258 VDPWR.t61 VDPWR.n1374 15.0005
R259 VDPWR.t61 VDPWR.n1375 15.0005
R260 VDPWR.t63 VDPWR.n1361 15.0005
R261 VDPWR.t63 VDPWR.n1353 15.0005
R262 VDPWR.n1362 VDPWR.t63 15.0005
R263 VDPWR.t63 VDPWR.n1354 15.0005
R264 VDPWR.t63 VDPWR.n1360 15.0005
R265 VDPWR.t63 VDPWR.n1355 15.0005
R266 VDPWR.t63 VDPWR.n1358 15.0005
R267 VDPWR.t63 VDPWR.n1356 15.0005
R268 VDPWR.t63 VDPWR.n1357 15.0005
R269 VDPWR.t63 VDPWR.t64 15.0005
R270 VDPWR.t65 VDPWR.n1343 15.0005
R271 VDPWR.t65 VDPWR.n1334 15.0005
R272 VDPWR.t65 VDPWR.n1342 15.0005
R273 VDPWR.t65 VDPWR.n1335 15.0005
R274 VDPWR.t65 VDPWR.n1340 15.0005
R275 VDPWR.t65 VDPWR.n1336 15.0005
R276 VDPWR.t65 VDPWR.n1339 15.0005
R277 VDPWR.t65 VDPWR.n1337 15.0005
R278 VDPWR.n1344 VDPWR.t65 15.0005
R279 VDPWR.t65 VDPWR.n1338 15.0005
R280 VDPWR.t73 VDPWR.n850 15.0005
R281 VDPWR.t73 VDPWR.n844 15.0005
R282 VDPWR.t73 VDPWR.n849 15.0005
R283 VDPWR.t73 VDPWR.n845 15.0005
R284 VDPWR.n851 VDPWR.t73 15.0005
R285 VDPWR.t73 VDPWR.n846 15.0005
R286 VDPWR.t73 VDPWR.n848 15.0005
R287 VDPWR.t73 VDPWR.n847 15.0005
R288 VDPWR.n1453 VDPWR.n507 9.63299
R289 VDPWR.n513 VDPWR.n505 9.63299
R290 VDPWR.n1459 VDPWR.t34 9.63227
R291 VDPWR.n986 VDPWR.n985 9.0005
R292 VDPWR.n985 VDPWR.n727 9.0005
R293 VDPWR.n985 VDPWR.n984 9.0005
R294 VDPWR.n985 VDPWR.n729 9.0005
R295 VDPWR.n985 VDPWR.n982 9.0005
R296 VDPWR.n985 VDPWR.n731 9.0005
R297 VDPWR.n977 VDPWR.n732 9.0005
R298 VDPWR.n977 VDPWR.n733 9.0005
R299 VDPWR.n977 VDPWR.n734 9.0005
R300 VDPWR.n977 VDPWR.n735 9.0005
R301 VDPWR.n977 VDPWR.n736 9.0005
R302 VDPWR.n977 VDPWR.n976 9.0005
R303 VDPWR.n924 VDPWR.n923 8.5285
R304 VDPWR.n1071 VDPWR.n1070 8.5089
R305 VDPWR.t33 VDPWR.n532 8.5089
R306 VDPWR.n685 VDPWR.n683 8.501
R307 VDPWR.n685 VDPWR.n678 8.501
R308 VDPWR.n685 VDPWR.n679 8.501
R309 VDPWR.n685 VDPWR.n676 8.501
R310 VDPWR.n685 VDPWR.n677 8.501
R311 VDPWR.n685 VDPWR.n682 8.501
R312 VDPWR.n685 VDPWR.n681 8.501
R313 VDPWR.n326 VDPWR.n325 8.501
R314 VDPWR.n289 VDPWR.n285 8.501
R315 VDPWR.n1071 VDPWR.n1031 8.50095
R316 VDPWR.n975 VDPWR.n685 8.50093
R317 VDPWR.n932 VDPWR.n685 8.50093
R318 VDPWR.n972 VDPWR.n685 8.50093
R319 VDPWR.n970 VDPWR.n685 8.50093
R320 VDPWR.n968 VDPWR.n685 8.50093
R321 VDPWR.n935 VDPWR.n685 8.50093
R322 VDPWR.n936 VDPWR.n685 8.50093
R323 VDPWR.n995 VDPWR.n666 8.50093
R324 VDPWR.n995 VDPWR.n667 8.50093
R325 VDPWR.n995 VDPWR.n668 8.50093
R326 VDPWR.n995 VDPWR.n669 8.50093
R327 VDPWR.n995 VDPWR.n670 8.50093
R328 VDPWR.n995 VDPWR.n671 8.50093
R329 VDPWR.n995 VDPWR.n672 8.50093
R330 VDPWR.n995 VDPWR.n673 8.50093
R331 VDPWR.n995 VDPWR.n674 8.50093
R332 VDPWR.n995 VDPWR.n675 8.50093
R333 VDPWR.n995 VDPWR.n663 8.50093
R334 VDPWR.n995 VDPWR.n662 8.50093
R335 VDPWR.n995 VDPWR.n661 8.50093
R336 VDPWR.n995 VDPWR.n660 8.50093
R337 VDPWR.n995 VDPWR.n659 8.50093
R338 VDPWR.n995 VDPWR.n658 8.50093
R339 VDPWR.n995 VDPWR.n657 8.50093
R340 VDPWR.n995 VDPWR.n656 8.50093
R341 VDPWR.n995 VDPWR.n655 8.50093
R342 VDPWR.n995 VDPWR.n654 8.50093
R343 VDPWR.n995 VDPWR.n653 8.50093
R344 VDPWR.n995 VDPWR.n652 8.50093
R345 VDPWR.n966 VDPWR.n685 8.50093
R346 VDPWR.n963 VDPWR.n685 8.50093
R347 VDPWR.n964 VDPWR.n685 8.50093
R348 VDPWR.n960 VDPWR.n685 8.50093
R349 VDPWR.n961 VDPWR.n685 8.50093
R350 VDPWR.n957 VDPWR.n685 8.50093
R351 VDPWR.n958 VDPWR.n685 8.50093
R352 VDPWR.n954 VDPWR.n685 8.50093
R353 VDPWR.n955 VDPWR.n685 8.50093
R354 VDPWR.n951 VDPWR.n685 8.50093
R355 VDPWR.n952 VDPWR.n685 8.50093
R356 VDPWR.n948 VDPWR.n685 8.50093
R357 VDPWR.n949 VDPWR.n685 8.50093
R358 VDPWR.n945 VDPWR.n685 8.50093
R359 VDPWR.n1071 VDPWR.n1036 8.50089
R360 VDPWR.n1071 VDPWR.n1035 8.50089
R361 VDPWR.n1071 VDPWR.n1034 8.50089
R362 VDPWR.n1071 VDPWR.n1033 8.50089
R363 VDPWR.n1071 VDPWR.n1032 8.50089
R364 VDPWR.n1072 VDPWR.n1071 8.50062
R365 VDPWR.n1071 VDPWR.n1030 8.5005
R366 VDPWR.n1071 VDPWR.n1029 8.5005
R367 VDPWR.n1071 VDPWR.n1028 8.5005
R368 VDPWR.n1071 VDPWR.n1027 8.5005
R369 VDPWR.n1071 VDPWR.n1026 8.5005
R370 VDPWR.n1071 VDPWR.n1025 8.5005
R371 VDPWR.n1071 VDPWR.n1024 8.5005
R372 VDPWR.n1071 VDPWR.n1023 8.5005
R373 VDPWR.n995 VDPWR.n639 8.5005
R374 VDPWR.n995 VDPWR.n650 8.5005
R375 VDPWR.n995 VDPWR.n640 8.5005
R376 VDPWR.n995 VDPWR.n649 8.5005
R377 VDPWR.n995 VDPWR.n641 8.5005
R378 VDPWR.n995 VDPWR.t49 8.5005
R379 VDPWR.n995 VDPWR.n643 8.5005
R380 VDPWR.n900 VDPWR.n899 8.5005
R381 VDPWR.n901 VDPWR.n900 8.5005
R382 VDPWR.n906 VDPWR.n905 8.5005
R383 VDPWR.n907 VDPWR.n906 8.5005
R384 VDPWR.n910 VDPWR.n909 8.5005
R385 VDPWR.n911 VDPWR.n910 8.5005
R386 VDPWR.n914 VDPWR.n913 8.5005
R387 VDPWR.n915 VDPWR.n914 8.5005
R388 VDPWR.n726 VDPWR.n685 8.5005
R389 VDPWR.n730 VDPWR.n685 8.5005
R390 VDPWR.n696 VDPWR.n685 8.5005
R391 VDPWR.n981 VDPWR.n685 8.5005
R392 VDPWR.n728 VDPWR.n685 8.5005
R393 VDPWR.n692 VDPWR.n685 8.5005
R394 VDPWR.n983 VDPWR.n685 8.5005
R395 VDPWR.n689 VDPWR.n685 8.5005
R396 VDPWR.n706 VDPWR.n685 8.5005
R397 VDPWR.n709 VDPWR.n685 8.5005
R398 VDPWR.n708 VDPWR.n685 8.5005
R399 VDPWR.n712 VDPWR.n685 8.5005
R400 VDPWR.n711 VDPWR.n685 8.5005
R401 VDPWR.n715 VDPWR.n685 8.5005
R402 VDPWR.n714 VDPWR.n685 8.5005
R403 VDPWR.n718 VDPWR.n685 8.5005
R404 VDPWR.n717 VDPWR.n685 8.5005
R405 VDPWR.n721 VDPWR.n685 8.5005
R406 VDPWR.n720 VDPWR.n685 8.5005
R407 VDPWR.n724 VDPWR.n685 8.5005
R408 VDPWR.n723 VDPWR.n685 8.5005
R409 VDPWR.n987 VDPWR.n685 8.5005
R410 VDPWR.n812 VDPWR.n742 8.5005
R411 VDPWR.n813 VDPWR.n742 8.5005
R412 VDPWR.n809 VDPWR.n742 8.5005
R413 VDPWR.n810 VDPWR.n742 8.5005
R414 VDPWR.n806 VDPWR.n742 8.5005
R415 VDPWR.n807 VDPWR.n742 8.5005
R416 VDPWR.n803 VDPWR.n742 8.5005
R417 VDPWR.n804 VDPWR.n742 8.5005
R418 VDPWR.n743 VDPWR.n742 8.5005
R419 VDPWR.n745 VDPWR.n742 8.5005
R420 VDPWR.n747 VDPWR.n742 8.5005
R421 VDPWR.n749 VDPWR.n742 8.5005
R422 VDPWR.n751 VDPWR.n742 8.5005
R423 VDPWR.n753 VDPWR.n742 8.5005
R424 VDPWR.n755 VDPWR.n742 8.5005
R425 VDPWR.n757 VDPWR.n742 8.5005
R426 VDPWR.n759 VDPWR.n742 8.5005
R427 VDPWR.n761 VDPWR.n742 8.5005
R428 VDPWR.n763 VDPWR.n742 8.5005
R429 VDPWR.n765 VDPWR.n742 8.5005
R430 VDPWR.n815 VDPWR.n742 8.5005
R431 VDPWR.n816 VDPWR.n742 8.5005
R432 VDPWR.t33 VDPWR.n538 8.5005
R433 VDPWR.n539 VDPWR.t33 8.5005
R434 VDPWR.t33 VDPWR.n519 8.5005
R435 VDPWR.t1 VDPWR.n524 8.5005
R436 VDPWR.n499 VDPWR.n191 8.5005
R437 VDPWR.n500 VDPWR.n499 8.5005
R438 VDPWR.n487 VDPWR.n361 8.5005
R439 VDPWR.n486 VDPWR.n478 8.5005
R440 VDPWR.n486 VDPWR.n453 8.5005
R441 VDPWR.n486 VDPWR.n477 8.5005
R442 VDPWR.n486 VDPWR.n454 8.5005
R443 VDPWR.n486 VDPWR.n476 8.5005
R444 VDPWR.n486 VDPWR.n456 8.5005
R445 VDPWR.n486 VDPWR.n475 8.5005
R446 VDPWR.n486 VDPWR.n457 8.5005
R447 VDPWR.n486 VDPWR.n469 8.5005
R448 VDPWR.n486 VDPWR.n468 8.5005
R449 VDPWR.n486 VDPWR.n459 8.5005
R450 VDPWR.n486 VDPWR.n461 8.5005
R451 VDPWR.n328 VDPWR.n286 8.5005
R452 VDPWR.n495 VDPWR.n220 8.5005
R453 VDPWR.n327 VDPWR.n220 8.5005
R454 VDPWR.n287 VDPWR.n284 8.5005
R455 VDPWR.n327 VDPWR.n284 8.5005
R456 VDPWR.n327 VDPWR.n316 8.5005
R457 VDPWR.n327 VDPWR.n314 8.5005
R458 VDPWR.n327 VDPWR.n313 8.5005
R459 VDPWR.n327 VDPWR.n306 8.5005
R460 VDPWR.n327 VDPWR.n305 8.5005
R461 VDPWR.n327 VDPWR.n304 8.5005
R462 VDPWR.n327 VDPWR.n303 8.5005
R463 VDPWR.n327 VDPWR.n295 8.5005
R464 VDPWR.n327 VDPWR.n294 8.5005
R465 VDPWR.n327 VDPWR.n293 8.5005
R466 VDPWR.n327 VDPWR.n292 8.5005
R467 VDPWR.n327 VDPWR.n291 8.5005
R468 VDPWR.t33 VDPWR.n516 8.50005
R469 VDPWR.t33 VDPWR.n515 8.49985
R470 VDPWR.t33 VDPWR.n511 8.49985
R471 VDPWR.t33 VDPWR.n521 8.49985
R472 VDPWR.n793 VDPWR.t50 8.49627
R473 VDPWR.n1430 VDPWR.n1008 8.49537
R474 VDPWR.n1430 VDPWR.n626 8.49531
R475 VDPWR.n1430 VDPWR.n606 8.49531
R476 VDPWR.n1430 VDPWR.n602 8.49531
R477 VDPWR.n1430 VDPWR.n633 8.48461
R478 VDPWR.n1430 VDPWR.n577 8.48078
R479 VDPWR.n1430 VDPWR.n620 8.47359
R480 VDPWR.n1430 VDPWR.n617 8.47359
R481 VDPWR.t75 VDPWR.n1058 7.49575
R482 VDPWR.t61 VDPWR.n1373 7.49575
R483 VDPWR.n537 VDPWR.n503 7.07444
R484 VDPWR.n541 VDPWR.n540 7.0721
R485 VDPWR.n685 VDPWR.n680 5.66778
R486 VDPWR.n452 VDPWR.n451 5.66778
R487 VDPWR.n325 VDPWR.n221 5.66778
R488 VDPWR.n289 VDPWR.n288 5.66778
R489 VDPWR.n896 VDPWR.n645 5.66767
R490 VDPWR.n895 VDPWR.n685 5.66767
R491 VDPWR.n995 VDPWR.n651 5.66717
R492 VDPWR.n995 VDPWR.n642 5.66717
R493 VDPWR.n860 VDPWR.n821 5.66717
R494 VDPWR.n995 VDPWR.n664 5.66717
R495 VDPWR.n992 VDPWR.n687 5.66717
R496 VDPWR.n928 VDPWR.n739 5.66717
R497 VDPWR.n487 VDPWR.n486 5.66717
R498 VDPWR.n495 VDPWR.n359 5.66717
R499 VDPWR.n1430 VDPWR.n596 5.62097
R500 VDPWR.n1430 VDPWR.n622 5.61923
R501 VDPWR.n1430 VDPWR.n621 5.61923
R502 VDPWR.n1430 VDPWR.n552 5.61856
R503 VDPWR.n1430 VDPWR.n553 5.61856
R504 VDPWR.n1430 VDPWR.n554 5.61856
R505 VDPWR.n1430 VDPWR.n597 5.61856
R506 VDPWR.n538 VDPWR.n537 4.53951
R507 VDPWR.n540 VDPWR.n539 4.53875
R508 VDPWR.n540 VDPWR.n508 4.53035
R509 VDPWR.n537 VDPWR.n536 4.53035
R510 VDPWR.t50 VDPWR.n792 4.31972
R511 VDPWR.n358 VDPWR.n357 4.26309
R512 VDPWR.n898 VDPWR.t48 4.251
R513 VDPWR.n891 VDPWR.n840 4.251
R514 VDPWR.t46 VDPWR.n839 4.251
R515 VDPWR.n888 VDPWR.n835 4.251
R516 VDPWR.n886 VDPWR.n834 4.251
R517 VDPWR.n884 VDPWR.n830 4.251
R518 VDPWR.t45 VDPWR.n829 4.251
R519 VDPWR.n878 VDPWR.n857 4.251
R520 VDPWR.n876 VDPWR.n858 4.251
R521 VDPWR.n791 VDPWR.n665 4.251
R522 VDPWR.n991 VDPWR.n990 4.251
R523 VDPWR.n894 VDPWR.n685 4.251
R524 VDPWR.n890 VDPWR.n685 4.251
R525 VDPWR.n883 VDPWR.n685 4.251
R526 VDPWR.n877 VDPWR.n685 4.251
R527 VDPWR.n873 VDPWR.n685 4.251
R528 VDPWR.n871 VDPWR.n685 4.251
R529 VDPWR.n870 VDPWR.n685 4.251
R530 VDPWR.n866 VDPWR.n685 4.251
R531 VDPWR.n865 VDPWR.n685 4.251
R532 VDPWR.n861 VDPWR.n685 4.251
R533 VDPWR.n889 VDPWR.n685 4.251
R534 VDPWR.n887 VDPWR.n685 4.251
R535 VDPWR.n885 VDPWR.n685 4.251
R536 VDPWR.n882 VDPWR.n685 4.251
R537 VDPWR.n868 VDPWR.n685 4.251
R538 VDPWR.n801 VDPWR.n740 4.251
R539 VDPWR.n493 VDPWR.n492 4.251
R540 VDPWR.n363 VDPWR.n362 4.251
R541 VDPWR.n446 VDPWR.n445 4.251
R542 VDPWR.n438 VDPWR.n437 4.251
R543 VDPWR.n432 VDPWR.n431 4.251
R544 VDPWR.n429 VDPWR.n428 4.251
R545 VDPWR.n372 VDPWR.n371 4.251
R546 VDPWR.n423 VDPWR.n422 4.251
R547 VDPWR.n376 VDPWR.n375 4.251
R548 VDPWR.n417 VDPWR.n416 4.251
R549 VDPWR.n414 VDPWR.n413 4.251
R550 VDPWR.n378 VDPWR.t14 4.251
R551 VDPWR.n408 VDPWR.n407 4.251
R552 VDPWR.n405 VDPWR.n404 4.251
R553 VDPWR.n397 VDPWR.n396 4.251
R554 VDPWR.n391 VDPWR.n390 4.251
R555 VDPWR.n388 VDPWR.n387 4.251
R556 VDPWR.n498 VDPWR.n497 4.251
R557 VDPWR.n196 VDPWR.n193 4.251
R558 VDPWR.n261 VDPWR.t11 4.251
R559 VDPWR.n251 VDPWR.n250 4.251
R560 VDPWR.n248 VDPWR.n247 4.251
R561 VDPWR.n245 VDPWR.n244 4.251
R562 VDPWR.n242 VDPWR.n241 4.251
R563 VDPWR.n237 VDPWR.n236 4.251
R564 VDPWR.n336 VDPWR.t8 4.251
R565 VDPWR.n495 VDPWR.n354 4.251
R566 VDPWR.n495 VDPWR.n352 4.251
R567 VDPWR.n495 VDPWR.n350 4.251
R568 VDPWR.n495 VDPWR.n349 4.251
R569 VDPWR.n495 VDPWR.n348 4.251
R570 VDPWR.n495 VDPWR.n346 4.251
R571 VDPWR.n495 VDPWR.n345 4.251
R572 VDPWR.n496 VDPWR.n495 4.251
R573 VDPWR.n495 VDPWR.n231 4.251
R574 VDPWR.n495 VDPWR.n229 4.251
R575 VDPWR.n495 VDPWR.n228 4.251
R576 VDPWR.n495 VDPWR.n224 4.251
R577 VDPWR.n495 VDPWR.n199 4.251
R578 VDPWR.n495 VDPWR.n200 4.251
R579 VDPWR.n495 VDPWR.n201 4.251
R580 VDPWR.n495 VDPWR.n203 4.251
R581 VDPWR.n495 VDPWR.n204 4.251
R582 VDPWR.n495 VDPWR.n205 4.251
R583 VDPWR.n495 VDPWR.n206 4.251
R584 VDPWR.n495 VDPWR.n208 4.251
R585 VDPWR.n495 VDPWR.n195 4.251
R586 VDPWR.n495 VDPWR.n211 4.251
R587 VDPWR.n495 VDPWR.n212 4.251
R588 VDPWR.n495 VDPWR.n213 4.251
R589 VDPWR.n495 VDPWR.n218 4.251
R590 VDPWR.n495 VDPWR.n219 4.251
R591 VDPWR.n872 VDPWR.n821 4.2505
R592 VDPWR.t40 VDPWR.n821 4.2505
R593 VDPWR.n869 VDPWR.n821 4.2505
R594 VDPWR.n867 VDPWR.n821 4.2505
R595 VDPWR.t38 VDPWR.n821 4.2505
R596 VDPWR.n862 VDPWR.n821 4.2505
R597 VDPWR.n927 VDPWR.n685 4.2505
R598 VDPWR.n330 VDPWR.n282 4.2505
R599 VDPWR.n330 VDPWR.n329 4.2505
R600 VDPWR.n330 VDPWR.t3 4.2505
R601 VDPWR.n328 VDPWR.n287 4.2505
R602 VDPWR.n327 VDPWR.n323 4.24507
R603 VDPWR.n486 VDPWR.n462 4.24503
R604 VDPWR.n327 VDPWR.n315 4.24501
R605 VDPWR.n489 VDPWR.n361 4.23729
R606 VDPWR.n491 VDPWR.n490 4.23729
R607 VDPWR.n444 VDPWR.n443 4.23729
R608 VDPWR.n436 VDPWR.n435 4.23729
R609 VDPWR.n430 VDPWR.n370 4.23729
R610 VDPWR.n427 VDPWR.n426 4.23729
R611 VDPWR.n425 VDPWR.n424 4.23729
R612 VDPWR.n421 VDPWR.n420 4.23729
R613 VDPWR.n419 VDPWR.n418 4.23729
R614 VDPWR.n415 VDPWR.n377 4.23729
R615 VDPWR.n412 VDPWR.n411 4.23729
R616 VDPWR.n410 VDPWR.n409 4.23729
R617 VDPWR.n406 VDPWR.n379 4.23729
R618 VDPWR.n403 VDPWR.n402 4.23729
R619 VDPWR.n395 VDPWR.n394 4.23729
R620 VDPWR.n389 VDPWR.n386 4.23729
R621 VDPWR.n385 VDPWR.n194 4.23729
R622 VDPWR.n258 VDPWR.n192 4.23729
R623 VDPWR.n264 VDPWR.n256 4.23729
R624 VDPWR.n267 VDPWR.n249 4.23729
R625 VDPWR.n268 VDPWR.n246 4.23729
R626 VDPWR.n269 VDPWR.n243 4.23729
R627 VDPWR.n270 VDPWR.n240 4.23729
R628 VDPWR.n273 VDPWR.n272 4.23729
R629 VDPWR.n332 VDPWR.n278 4.23729
R630 VDPWR.n531 VDPWR.t1 4.23715
R631 VDPWR.n918 VDPWR.n824 4.2371
R632 VDPWR.n919 VDPWR.n823 4.2371
R633 VDPWR.n920 VDPWR.n822 4.2371
R634 VDPWR.n995 VDPWR.n644 4.23701
R635 VDPWR.n992 VDPWR.n686 4.23701
R636 VDPWR.n928 VDPWR.n738 4.23701
R637 VDPWR.n904 VDPWR.n841 4.23691
R638 VDPWR.n908 VDPWR.n836 4.23691
R639 VDPWR.n912 VDPWR.n831 4.23691
R640 VDPWR.t1 VDPWR.n528 4.23691
R641 VDPWR.n1071 VDPWR.n1068 4.23642
R642 VDPWR.n1071 VDPWR.n1053 4.23628
R643 VDPWR.t33 VDPWR.t36 4.23614
R644 VDPWR.t33 VDPWR.n512 4.23595
R645 VDPWR.t33 VDPWR.n520 4.23582
R646 VDPWR.n1430 VDPWR.n1010 4.22512
R647 VDPWR.n1430 VDPWR.n575 4.20261
R648 VDPWR.n1430 VDPWR.n634 4.19628
R649 VDPWR.n1157 VDPWR.n1154 3.73369
R650 VDPWR.t68 VDPWR.n1077 3.60528
R651 VDPWR.n989 VDPWR.t60 3.46429
R652 VDPWR.t53 VDPWR.n931 3.46429
R653 VDPWR.t39 VDPWR.n802 3.44446
R654 VDPWR.n897 VDPWR.n685 3.401
R655 VDPWR.n930 VDPWR.n929 3.401
R656 VDPWR.n1430 VDPWR.n1009 3.31386
R657 VDPWR.n7 VDPWR.n501 3.26974
R658 VDPWR.n893 VDPWR.n854 2.83444
R659 VDPWR.n881 VDPWR.n855 2.83444
R660 VDPWR.t43 VDPWR.n856 2.83444
R661 VDPWR.n892 VDPWR.n685 2.83444
R662 VDPWR.n880 VDPWR.n685 2.83444
R663 VDPWR.n863 VDPWR.n685 2.83444
R664 VDPWR.n366 VDPWR.n365 2.83444
R665 VDPWR.n440 VDPWR.n368 2.83444
R666 VDPWR.n369 VDPWR.t16 2.83444
R667 VDPWR.n381 VDPWR.n380 2.83444
R668 VDPWR.n399 VDPWR.n383 2.83444
R669 VDPWR.n384 VDPWR.t13 2.83444
R670 VDPWR.n259 VDPWR.n257 2.83444
R671 VDPWR.t11 VDPWR.n260 2.83444
R672 VDPWR.n254 VDPWR.n253 2.83444
R673 VDPWR.n239 VDPWR.t5 2.83444
R674 VDPWR.n274 VDPWR.n235 2.83444
R675 VDPWR.n276 VDPWR.n234 2.83444
R676 VDPWR.n338 VDPWR.n277 2.83444
R677 VDPWR.t8 VDPWR.n335 2.83444
R678 VDPWR.n495 VDPWR.n353 2.83444
R679 VDPWR.n495 VDPWR.n351 2.83444
R680 VDPWR.n495 VDPWR.n347 2.83444
R681 VDPWR.n495 VDPWR.n227 2.83444
R682 VDPWR.n495 VDPWR.n226 2.83444
R683 VDPWR.n495 VDPWR.n223 2.83444
R684 VDPWR.n495 VDPWR.n198 2.83444
R685 VDPWR.n495 VDPWR.n207 2.83444
R686 VDPWR.n495 VDPWR.n209 2.83444
R687 VDPWR.n495 VDPWR.n210 2.83444
R688 VDPWR.n495 VDPWR.n214 2.83444
R689 VDPWR.n495 VDPWR.n215 2.83444
R690 VDPWR.n495 VDPWR.n217 2.83444
R691 VDPWR.n879 VDPWR.n685 2.83433
R692 VDPWR.n495 VDPWR.n355 2.83433
R693 VDPWR.n864 VDPWR.n821 2.83383
R694 VDPWR.n330 VDPWR.n283 2.83383
R695 VDPWR.n361 VDPWR.n360 2.83383
R696 VDPWR.n486 VDPWR.n458 2.82384
R697 VDPWR.n327 VDPWR.n312 2.82381
R698 VDPWR.n327 VDPWR.n290 2.82381
R699 VDPWR.n486 VDPWR.n460 2.82365
R700 VDPWR.n819 VDPWR.n742 2.81017
R701 VDPWR.n450 VDPWR.n449 2.81017
R702 VDPWR.n447 VDPWR.n364 2.81017
R703 VDPWR.n442 VDPWR.n441 2.81017
R704 VDPWR.n439 VDPWR.n367 2.81017
R705 VDPWR.n434 VDPWR.n433 2.81017
R706 VDPWR.n401 VDPWR.n400 2.81017
R707 VDPWR.n398 VDPWR.n382 2.81017
R708 VDPWR.n393 VDPWR.n392 2.81017
R709 VDPWR.n263 VDPWR.n262 2.81017
R710 VDPWR.n265 VDPWR.n255 2.81017
R711 VDPWR.n266 VDPWR.n252 2.81017
R712 VDPWR.n271 VDPWR.n238 2.81017
R713 VDPWR.n275 VDPWR.n232 2.81017
R714 VDPWR.n340 VDPWR.n339 2.81017
R715 VDPWR.n337 VDPWR.n233 2.81017
R716 VDPWR.n334 VDPWR.n333 2.81017
R717 VDPWR.n917 VDPWR.n825 2.80984
R718 VDPWR.n902 VDPWR.n843 2.8095
R719 VDPWR.n916 VDPWR.n826 2.8095
R720 VDPWR.n1071 VDPWR.n1020 2.80871
R721 VDPWR.n1071 VDPWR.n1054 2.8082
R722 VDPWR.n618 VDPWR.t72 2.71333
R723 VDPWR.n623 VDPWR.t74 2.59426
R724 VDPWR.n280 VDPWR.n279 2.42957
R725 VDPWR.n979 VDPWR.t56 2.39719
R726 VDPWR.n980 VDPWR.t58 2.3971
R727 VDPWR.n978 VDPWR.t54 2.39697
R728 VDPWR.n797 VDPWR.t41 2.37591
R729 VDPWR.n796 VDPWR.t44 2.37569
R730 VDPWR.n795 VDPWR.t47 2.37557
R731 VDPWR.n4 VDPWR.n1464 2.32386
R732 VDPWR.n1158 VDPWR.n1153 2.22576
R733 VDPWR.n172 VDPWR.n5 1.10969
R734 VDPWR.n1 VDPWR.n35 2.2005
R735 VDPWR.n6 VDPWR.n83 2.2005
R736 VDPWR.n3 VDPWR.n172 2.2005
R737 VDPWR.n1467 VDPWR.n169 2.2005
R738 VDPWR.n170 VDPWR.n1468 2.2005
R739 VDPWR.n166 VDPWR.n168 2.2005
R740 VDPWR.n1471 VDPWR.n164 2.2005
R741 VDPWR.n165 VDPWR.n1472 2.2005
R742 VDPWR.n161 VDPWR.n163 2.2005
R743 VDPWR.n1475 VDPWR.n159 2.2005
R744 VDPWR.n160 VDPWR.n1476 2.2005
R745 VDPWR.n156 VDPWR.n158 2.2005
R746 VDPWR.n1479 VDPWR.n154 2.2005
R747 VDPWR.n155 VDPWR.n1480 2.2005
R748 VDPWR.n151 VDPWR.n153 2.2005
R749 VDPWR.n1483 VDPWR.n149 2.2005
R750 VDPWR.n150 VDPWR.n1484 2.2005
R751 VDPWR.n146 VDPWR.n148 2.2005
R752 VDPWR.n1487 VDPWR.n144 2.2005
R753 VDPWR.n145 VDPWR.n1488 2.2005
R754 VDPWR.n141 VDPWR.n143 2.2005
R755 VDPWR.n1491 VDPWR.n139 2.2005
R756 VDPWR.n140 VDPWR.n1492 2.2005
R757 VDPWR.n136 VDPWR.n138 2.2005
R758 VDPWR.n1495 VDPWR.n134 2.2005
R759 VDPWR.n135 VDPWR.n1496 2.2005
R760 VDPWR.n131 VDPWR.n133 2.2005
R761 VDPWR.n1499 VDPWR.n129 2.2005
R762 VDPWR.n130 VDPWR.n1500 2.2005
R763 VDPWR.n126 VDPWR.n128 2.2005
R764 VDPWR.n1503 VDPWR.n124 2.2005
R765 VDPWR.n125 VDPWR.n1504 2.2005
R766 VDPWR.n121 VDPWR.n123 2.2005
R767 VDPWR.n1507 VDPWR.n119 2.2005
R768 VDPWR.n120 VDPWR.n1508 2.2005
R769 VDPWR.n116 VDPWR.n118 2.2005
R770 VDPWR.n1511 VDPWR.n114 2.2005
R771 VDPWR.n115 VDPWR.n1512 2.2005
R772 VDPWR.n111 VDPWR.n113 2.2005
R773 VDPWR.n1515 VDPWR.n109 2.2005
R774 VDPWR.n110 VDPWR.n1516 2.2005
R775 VDPWR.n106 VDPWR.n108 2.2005
R776 VDPWR.n1519 VDPWR.n104 2.2005
R777 VDPWR.n105 VDPWR.n1520 2.2005
R778 VDPWR.n101 VDPWR.n103 2.2005
R779 VDPWR.n1523 VDPWR.n99 2.2005
R780 VDPWR.n100 VDPWR.n1524 2.2005
R781 VDPWR.n96 VDPWR.n98 2.2005
R782 VDPWR.n1527 VDPWR.n94 2.2005
R783 VDPWR.n95 VDPWR.n1528 2.2005
R784 VDPWR.n91 VDPWR.n93 2.2005
R785 VDPWR.n1531 VDPWR.n89 2.2005
R786 VDPWR.n90 VDPWR.n1532 2.2005
R787 VDPWR.n86 VDPWR.n88 2.2005
R788 VDPWR.n1535 VDPWR.n84 2.2005
R789 VDPWR.n85 VDPWR.n1536 2.2005
R790 VDPWR.n1539 VDPWR.n7 2.2005
R791 VDPWR.n1540 VDPWR.n80 2.2005
R792 VDPWR.n75 VDPWR.n79 1.10097
R793 VDPWR.n11 VDPWR.n76 1.10098
R794 VDPWR.n77 VDPWR.n14 1.10098
R795 VDPWR.n13 VDPWR.n78 1.10097
R796 VDPWR.n13 VDPWR.n12 0.00105998
R797 VDPWR.n73 VDPWR.n74 1.10097
R798 VDPWR.n188 VDPWR.n74 0.00105998
R799 VDPWR.n71 VDPWR.n72 1.10097
R800 VDPWR.n187 VDPWR.n72 0.00105998
R801 VDPWR.n69 VDPWR.n70 1.10097
R802 VDPWR.n186 VDPWR.n70 0.00105998
R803 VDPWR.n67 VDPWR.n68 1.10097
R804 VDPWR.n15 VDPWR.n68 0.00105998
R805 VDPWR.n63 VDPWR.n17 1.10097
R806 VDPWR.n16 VDPWR.n64 1.10098
R807 VDPWR.n65 VDPWR.n23 1.10098
R808 VDPWR.n22 VDPWR.n66 1.10097
R809 VDPWR.n22 VDPWR.n21 0.00105998
R810 VDPWR.n61 VDPWR.n62 1.10097
R811 VDPWR.n185 VDPWR.n62 0.00105998
R812 VDPWR.n59 VDPWR.n60 1.10097
R813 VDPWR.n184 VDPWR.n60 0.00105998
R814 VDPWR.n57 VDPWR.n58 1.10097
R815 VDPWR.n183 VDPWR.n58 0.00105998
R816 VDPWR.n55 VDPWR.n56 1.10097
R817 VDPWR.n182 VDPWR.n56 0.00105998
R818 VDPWR.n53 VDPWR.n54 1.10097
R819 VDPWR.n24 VDPWR.n54 0.00105998
R820 VDPWR.n49 VDPWR.n26 1.10097
R821 VDPWR.n25 VDPWR.n50 1.10098
R822 VDPWR.n51 VDPWR.n33 1.10098
R823 VDPWR.n32 VDPWR.n52 1.10097
R824 VDPWR.n32 VDPWR.n31 0.00105998
R825 VDPWR.n47 VDPWR.n48 1.10097
R826 VDPWR.n181 VDPWR.n48 0.00105998
R827 VDPWR.n45 VDPWR.n46 1.10097
R828 VDPWR.n180 VDPWR.n46 0.00105998
R829 VDPWR.n43 VDPWR.n44 1.10097
R830 VDPWR.n179 VDPWR.n44 0.00105998
R831 VDPWR.n41 VDPWR.n42 1.10097
R832 VDPWR.n178 VDPWR.n42 0.00105998
R833 VDPWR.n39 VDPWR.n40 1.10097
R834 VDPWR.n176 VDPWR.n40 0.00105998
R835 VDPWR.n38 VDPWR.n34 1.10097
R836 VDPWR.n38 VDPWR.n174 0.00105998
R837 VDPWR.n37 VDPWR.n36 1.10097
R838 VDPWR.n37 VDPWR.n0 0.00105998
R839 VDPWR.n4 VDPWR.n5 0.00225978
R840 VDPWR.n2 VDPWR.n1 0.00303734
R841 VDPWR.n3 VDPWR.n1466 2.2005
R842 VDPWR.n169 VDPWR.n171 2.2005
R843 VDPWR.n1469 VDPWR.n170 2.2005
R844 VDPWR.n166 VDPWR.n1470 2.2005
R845 VDPWR.n164 VDPWR.n167 2.2005
R846 VDPWR.n1473 VDPWR.n165 2.2005
R847 VDPWR.n161 VDPWR.n1474 2.2005
R848 VDPWR.n159 VDPWR.n162 2.2005
R849 VDPWR.n1477 VDPWR.n160 2.2005
R850 VDPWR.n156 VDPWR.n1478 2.2005
R851 VDPWR.n154 VDPWR.n157 2.2005
R852 VDPWR.n1481 VDPWR.n155 2.2005
R853 VDPWR.n151 VDPWR.n1482 2.2005
R854 VDPWR.n149 VDPWR.n152 2.2005
R855 VDPWR.n1485 VDPWR.n150 2.2005
R856 VDPWR.n146 VDPWR.n1486 2.2005
R857 VDPWR.n144 VDPWR.n147 2.2005
R858 VDPWR.n1489 VDPWR.n145 2.2005
R859 VDPWR.n141 VDPWR.n1490 2.2005
R860 VDPWR.n139 VDPWR.n142 2.2005
R861 VDPWR.n1493 VDPWR.n140 2.2005
R862 VDPWR.n136 VDPWR.n1494 2.2005
R863 VDPWR.n134 VDPWR.n137 2.2005
R864 VDPWR.n1497 VDPWR.n135 2.2005
R865 VDPWR.n131 VDPWR.n1498 2.2005
R866 VDPWR.n129 VDPWR.n132 2.2005
R867 VDPWR.n1501 VDPWR.n130 2.2005
R868 VDPWR.n126 VDPWR.n1502 2.2005
R869 VDPWR.n124 VDPWR.n127 2.2005
R870 VDPWR.n1505 VDPWR.n125 2.2005
R871 VDPWR.n121 VDPWR.n1506 2.2005
R872 VDPWR.n119 VDPWR.n122 2.2005
R873 VDPWR.n1509 VDPWR.n120 2.2005
R874 VDPWR.n116 VDPWR.n1510 2.2005
R875 VDPWR.n114 VDPWR.n117 2.2005
R876 VDPWR.n1513 VDPWR.n115 2.2005
R877 VDPWR.n111 VDPWR.n1514 2.2005
R878 VDPWR.n109 VDPWR.n112 2.2005
R879 VDPWR.n1517 VDPWR.n110 2.2005
R880 VDPWR.n106 VDPWR.n1518 2.2005
R881 VDPWR.n104 VDPWR.n107 2.2005
R882 VDPWR.n1521 VDPWR.n105 2.2005
R883 VDPWR.n101 VDPWR.n1522 2.2005
R884 VDPWR.n99 VDPWR.n102 2.2005
R885 VDPWR.n1525 VDPWR.n100 2.2005
R886 VDPWR.n96 VDPWR.n1526 2.2005
R887 VDPWR.n94 VDPWR.n97 2.2005
R888 VDPWR.n1529 VDPWR.n95 2.2005
R889 VDPWR.n91 VDPWR.n1530 2.2005
R890 VDPWR.n89 VDPWR.n92 2.2005
R891 VDPWR.n1533 VDPWR.n90 2.2005
R892 VDPWR.n86 VDPWR.n1534 2.2005
R893 VDPWR.n84 VDPWR.n87 2.2005
R894 VDPWR.n1537 VDPWR.n85 2.2005
R895 VDPWR.n6 VDPWR.n1538 2.2005
R896 VDPWR.n7 VDPWR.n82 2.2005
R897 VDPWR.n80 VDPWR.n1543 2.2005
R898 VDPWR.n9 VDPWR.n189 1.10098
R899 VDPWR.n11 VDPWR.n10 1.10098
R900 VDPWR.n1544 VDPWR.n14 2.2005
R901 VDPWR.n14 VDPWR.t79 2.2005
R902 VDPWR.n1544 VDPWR.n12 2.2005
R903 VDPWR.n12 VDPWR.t79 2.2005
R904 VDPWR.n1544 VDPWR.n188 2.2005
R905 VDPWR.n188 VDPWR.t79 2.2005
R906 VDPWR.n1544 VDPWR.n187 2.2005
R907 VDPWR.n187 VDPWR.t79 2.2005
R908 VDPWR.n1544 VDPWR.n186 2.2005
R909 VDPWR.n186 VDPWR.t79 2.2005
R910 VDPWR.n1544 VDPWR.n15 2.2005
R911 VDPWR.n15 VDPWR.n1545 2.2005
R912 VDPWR.n19 VDPWR.n17 1.10098
R913 VDPWR.n16 VDPWR.n20 1.10098
R914 VDPWR.n1546 VDPWR.n23 2.2005
R915 VDPWR.n23 VDPWR.t78 2.2005
R916 VDPWR.n1546 VDPWR.n21 2.2005
R917 VDPWR.n21 VDPWR.t78 2.2005
R918 VDPWR.n1546 VDPWR.n185 2.2005
R919 VDPWR.n185 VDPWR.t78 2.2005
R920 VDPWR.n1546 VDPWR.n184 2.2005
R921 VDPWR.n184 VDPWR.t78 2.2005
R922 VDPWR.n1546 VDPWR.n183 2.2005
R923 VDPWR.n183 VDPWR.t78 2.2005
R924 VDPWR.n1546 VDPWR.n182 2.2005
R925 VDPWR.n182 VDPWR.t78 2.2005
R926 VDPWR.n24 VDPWR.n28 1.10098
R927 VDPWR.n29 VDPWR.n26 1.10098
R928 VDPWR.n25 VDPWR.n30 1.10098
R929 VDPWR.n1547 VDPWR.n33 2.2005
R930 VDPWR.n33 VDPWR.t77 2.2005
R931 VDPWR.n1547 VDPWR.n31 2.2005
R932 VDPWR.n31 VDPWR.t77 2.2005
R933 VDPWR.n1547 VDPWR.n181 2.2005
R934 VDPWR.n181 VDPWR.t77 2.2005
R935 VDPWR.n1547 VDPWR.n180 2.2005
R936 VDPWR.n180 VDPWR.t77 2.2005
R937 VDPWR.n1547 VDPWR.n179 2.2005
R938 VDPWR.n179 VDPWR.t77 2.2005
R939 VDPWR.n1547 VDPWR.n178 2.2005
R940 VDPWR.n178 VDPWR.t77 2.2005
R941 VDPWR.n176 VDPWR.n177 1.10098
R942 VDPWR.n175 VDPWR.n174 1.10098
R943 VDPWR.n0 VDPWR.n173 1.10098
R944 VDPWR.n1157 VDPWR.n1156 2.2005
R945 VDPWR.n1159 VDPWR.n1152 2.2005
R946 VDPWR.n1161 VDPWR.n1160 2.2005
R947 VDPWR.n1162 VDPWR.n1151 2.2005
R948 VDPWR.n1164 VDPWR.n1163 2.2005
R949 VDPWR.n1165 VDPWR.n1150 2.2005
R950 VDPWR.n1167 VDPWR.n1166 2.2005
R951 VDPWR.n1168 VDPWR.n1149 2.2005
R952 VDPWR.n1170 VDPWR.n1169 2.2005
R953 VDPWR.n1171 VDPWR.n1148 2.2005
R954 VDPWR.n1173 VDPWR.n1172 2.2005
R955 VDPWR.n1174 VDPWR.n1147 2.2005
R956 VDPWR.n1176 VDPWR.n1175 2.2005
R957 VDPWR.n1177 VDPWR.n1146 2.2005
R958 VDPWR.n1179 VDPWR.n1178 2.2005
R959 VDPWR.n1180 VDPWR.n1145 2.2005
R960 VDPWR.n1182 VDPWR.n1181 2.2005
R961 VDPWR.n1183 VDPWR.n1144 2.2005
R962 VDPWR.n1185 VDPWR.n1184 2.2005
R963 VDPWR.n1186 VDPWR.n1143 2.2005
R964 VDPWR.n1188 VDPWR.n1187 2.2005
R965 VDPWR.n1189 VDPWR.n1142 2.2005
R966 VDPWR.n1191 VDPWR.n1190 2.2005
R967 VDPWR.n1192 VDPWR.n1141 2.2005
R968 VDPWR.n1194 VDPWR.n1193 2.2005
R969 VDPWR.n1195 VDPWR.n1140 2.2005
R970 VDPWR.n1197 VDPWR.n1196 2.2005
R971 VDPWR.n1198 VDPWR.n1139 2.2005
R972 VDPWR.n1200 VDPWR.n1199 2.2005
R973 VDPWR.n1201 VDPWR.n1138 2.2005
R974 VDPWR.n1203 VDPWR.n1202 2.2005
R975 VDPWR.n1204 VDPWR.n1137 2.2005
R976 VDPWR.n1206 VDPWR.n1205 2.2005
R977 VDPWR.n1207 VDPWR.n1136 2.2005
R978 VDPWR.n1209 VDPWR.n1208 2.2005
R979 VDPWR.n1210 VDPWR.n1135 2.2005
R980 VDPWR.n1212 VDPWR.n1211 2.2005
R981 VDPWR.n1213 VDPWR.n1134 2.2005
R982 VDPWR.n1215 VDPWR.n1214 2.2005
R983 VDPWR.n1216 VDPWR.n1133 2.2005
R984 VDPWR.n1218 VDPWR.n1217 2.2005
R985 VDPWR.n1219 VDPWR.n1132 2.2005
R986 VDPWR.n1221 VDPWR.n1220 2.2005
R987 VDPWR.n1222 VDPWR.n1131 2.2005
R988 VDPWR.n1224 VDPWR.n1223 2.2005
R989 VDPWR.n1225 VDPWR.n1130 2.2005
R990 VDPWR.n1227 VDPWR.n1226 2.2005
R991 VDPWR.n1228 VDPWR.n1129 2.2005
R992 VDPWR.n1230 VDPWR.n1229 2.2005
R993 VDPWR.n1231 VDPWR.n1128 2.2005
R994 VDPWR.n1233 VDPWR.n1232 2.2005
R995 VDPWR.n1234 VDPWR.n1127 2.2005
R996 VDPWR.n1236 VDPWR.n1235 2.2005
R997 VDPWR.n1237 VDPWR.n1126 2.2005
R998 VDPWR.n1239 VDPWR.n1238 2.2005
R999 VDPWR.n1240 VDPWR.n1125 2.2005
R1000 VDPWR.n1242 VDPWR.n1241 2.2005
R1001 VDPWR.n1245 VDPWR.n1244 2.2005
R1002 VDPWR.n1246 VDPWR.n1123 2.2005
R1003 VDPWR.n1248 VDPWR.n1247 2.2005
R1004 VDPWR.n1249 VDPWR.n1122 2.2005
R1005 VDPWR.n1251 VDPWR.n1250 2.2005
R1006 VDPWR.n1252 VDPWR.n1121 2.2005
R1007 VDPWR.n1254 VDPWR.n1253 2.2005
R1008 VDPWR.n1255 VDPWR.n1120 2.2005
R1009 VDPWR.n1257 VDPWR.n1256 2.2005
R1010 VDPWR.n1258 VDPWR.n1119 2.2005
R1011 VDPWR.n1260 VDPWR.n1259 2.2005
R1012 VDPWR.n1261 VDPWR.n1118 2.2005
R1013 VDPWR.n1263 VDPWR.n1262 2.2005
R1014 VDPWR.n1264 VDPWR.n1117 2.2005
R1015 VDPWR.n1266 VDPWR.n1265 2.2005
R1016 VDPWR.n1267 VDPWR.n1116 2.2005
R1017 VDPWR.n1269 VDPWR.n1268 2.2005
R1018 VDPWR.n1270 VDPWR.n1115 2.2005
R1019 VDPWR.n1272 VDPWR.n1271 2.2005
R1020 VDPWR.n1273 VDPWR.n1114 2.2005
R1021 VDPWR.n1275 VDPWR.n1274 2.2005
R1022 VDPWR.n1276 VDPWR.n1113 2.2005
R1023 VDPWR.n1278 VDPWR.n1277 2.2005
R1024 VDPWR.n1279 VDPWR.n1112 2.2005
R1025 VDPWR.n1281 VDPWR.n1280 2.2005
R1026 VDPWR.n1282 VDPWR.n1111 2.2005
R1027 VDPWR.n1284 VDPWR.n1283 2.2005
R1028 VDPWR.n1285 VDPWR.n1110 2.2005
R1029 VDPWR.n1287 VDPWR.n1286 2.2005
R1030 VDPWR.n1288 VDPWR.n1109 2.2005
R1031 VDPWR.n1290 VDPWR.n1289 2.2005
R1032 VDPWR.n1291 VDPWR.n1108 2.2005
R1033 VDPWR.n1293 VDPWR.n1292 2.2005
R1034 VDPWR.n1294 VDPWR.n1107 2.2005
R1035 VDPWR.n1296 VDPWR.n1295 2.2005
R1036 VDPWR.n1297 VDPWR.n1106 2.2005
R1037 VDPWR.n1299 VDPWR.n1298 2.2005
R1038 VDPWR.n1300 VDPWR.n1105 2.2005
R1039 VDPWR.n1302 VDPWR.n1301 2.2005
R1040 VDPWR.n1303 VDPWR.n1104 2.2005
R1041 VDPWR.n1305 VDPWR.n1304 2.2005
R1042 VDPWR.n1306 VDPWR.n1103 2.2005
R1043 VDPWR.n1308 VDPWR.n1307 2.2005
R1044 VDPWR.n1309 VDPWR.n1102 2.2005
R1045 VDPWR.n1311 VDPWR.n1310 2.2005
R1046 VDPWR.n1312 VDPWR.n1101 2.2005
R1047 VDPWR.n1314 VDPWR.n1313 2.2005
R1048 VDPWR.n1315 VDPWR.n1100 2.2005
R1049 VDPWR.n1317 VDPWR.n1316 2.2005
R1050 VDPWR.n1318 VDPWR.n1099 2.2005
R1051 VDPWR.n1320 VDPWR.n1319 2.2005
R1052 VDPWR.n1321 VDPWR.n1098 2.2005
R1053 VDPWR.n1323 VDPWR.n1322 2.2005
R1054 VDPWR.n1324 VDPWR.n1097 2.2005
R1055 VDPWR.n1326 VDPWR.n1325 2.2005
R1056 VDPWR.n1327 VDPWR.n1096 2.2005
R1057 VDPWR.n1329 VDPWR.n1328 2.2005
R1058 VDPWR.n448 VDPWR.t17 2.12612
R1059 VDPWR.n495 VDPWR.n197 2.126
R1060 VDPWR.n495 VDPWR.n494 2.126
R1061 VDPWR.n486 VDPWR.n485 2.11149
R1062 VDPWR.n486 VDPWR.n455 2.11131
R1063 VDPWR.n327 VDPWR.n302 2.11121
R1064 VDPWR.n1071 VDPWR.n1022 2.09752
R1065 VDPWR.n995 VDPWR.n648 2.09118
R1066 VDPWR.n996 VDPWR.n995 2.09105
R1067 VDPWR.t6 VDPWR.t26 1.91575
R1068 VDPWR.t30 VDPWR.t22 1.91575
R1069 VDPWR.t20 VDPWR.t28 1.91575
R1070 VDPWR.t9 VDPWR.t6 1.87739
R1071 VDPWR.t22 VDPWR.t15 1.87739
R1072 VDPWR.t12 VDPWR.t20 1.87739
R1073 VDPWR.n618 VDPWR.t71 1.87261
R1074 VDPWR.t70 VDPWR.t62 1.84309
R1075 VDPWR.n637 VDPWR.n636 1.80015
R1076 VDPWR.n998 VDPWR.n997 1.80015
R1077 VDPWR.n833 VDPWR.n832 1.77474
R1078 VDPWR.n647 VDPWR.n646 1.77474
R1079 VDPWR.n853 VDPWR.n852 1.77474
R1080 VDPWR.n838 VDPWR.n837 1.7541
R1081 VDPWR.n828 VDPWR.n827 1.7541
R1082 VDPWR.n903 VDPWR.n842 1.7541
R1083 VDPWR.n875 VDPWR.n685 1.70096
R1084 VDPWR.n495 VDPWR.n230 1.70096
R1085 VDPWR.n495 VDPWR.n216 1.70096
R1086 VDPWR.n995 VDPWR.n635 1.66951
R1087 VDPWR.n1071 VDPWR.n1017 1.65516
R1088 VDPWR.t42 VDPWR.n874 1.5464
R1089 VDPWR.n798 VDPWR.n797 1.43298
R1090 VDPWR.n795 VDPWR.n794 1.43298
R1091 VDPWR.t26 VDPWR.n341 1.42349
R1092 VDPWR.n374 VDPWR.t30 1.42349
R1093 VDPWR.n501 VDPWR.t28 1.42349
R1094 VDPWR.n993 VDPWR.n992 1.41767
R1095 VDPWR.n928 VDPWR.n926 1.41767
R1096 VDPWR.n527 VDPWR.t37 1.40606
R1097 VDPWR.n525 VDPWR.t35 1.40606
R1098 VDPWR.t2 VDPWR.n519 1.38105
R1099 VDPWR.n523 VDPWR.n522 1.36807
R1100 VDPWR.n532 VDPWR.n529 1.36807
R1101 VDPWR.n1430 VDPWR.n999 1.36589
R1102 VDPWR.t33 VDPWR.n514 1.36081
R1103 VDPWR.n1077 VDPWR.t76 1.34371
R1104 VDPWR.n1429 VDPWR.n1011 1.25842
R1105 VDPWR.n1078 VDPWR.t68 1.23521
R1106 VDPWR.n1429 VDPWR.n1428 1.22562
R1107 VDPWR.n599 VDPWR.n598 1.22535
R1108 VDPWR.n1077 VDPWR.n1076 1.22114
R1109 VDPWR.n598 VDPWR.n545 1.19297
R1110 VDPWR.n1154 VDPWR.n1 1.18876
R1111 VDPWR.n330 VDPWR.n328 1.13383
R1112 VDPWR.n1330 VDPWR.n1012 1.12576
R1113 VDPWR.n342 VDPWR.t9 1.10672
R1114 VDPWR.t15 VDPWR.n373 1.10672
R1115 VDPWR.n343 VDPWR.t12 1.10672
R1116 VDPWR.n81 VDPWR.n1541 1.1005
R1117 VDPWR.n1542 VDPWR.n81 1.1005
R1118 VDPWR.n1243 VDPWR.n1124 1.1005
R1119 VDPWR.n1418 VDPWR.n1417 1.1005
R1120 VDPWR.n1416 VDPWR.n1095 1.1005
R1121 VDPWR.n1415 VDPWR.n1414 1.1005
R1122 VDPWR.n1412 VDPWR.n1331 1.1005
R1123 VDPWR.n1410 VDPWR.n1409 1.1005
R1124 VDPWR.n1408 VDPWR.n1407 1.1005
R1125 VDPWR.n1405 VDPWR.n1348 1.1005
R1126 VDPWR.n1404 VDPWR.n1403 1.1005
R1127 VDPWR.n1402 VDPWR.n1350 1.1005
R1128 VDPWR.n1401 VDPWR.n1400 1.1005
R1129 VDPWR.n1398 VDPWR.n1351 1.1005
R1130 VDPWR.n1396 VDPWR.n1395 1.1005
R1131 VDPWR.n1394 VDPWR.n1365 1.1005
R1132 VDPWR.n1393 VDPWR.n1392 1.1005
R1133 VDPWR.n1391 VDPWR.n1366 1.1005
R1134 VDPWR.n1390 VDPWR.n1389 1.1005
R1135 VDPWR.n1388 VDPWR.n1367 1.1005
R1136 VDPWR.n1387 VDPWR.n1386 1.1005
R1137 VDPWR.n1384 VDPWR.n1368 1.1005
R1138 VDPWR.n1382 VDPWR.n548 1.1005
R1139 VDPWR.n1435 VDPWR.n1434 1.1005
R1140 VDPWR.n1436 VDPWR.n547 1.1005
R1141 VDPWR.n1438 VDPWR.n1437 1.1005
R1142 VDPWR.n1440 VDPWR.n544 1.1005
R1143 VDPWR.n1443 VDPWR.n1442 1.1005
R1144 VDPWR.n1444 VDPWR.n543 1.1005
R1145 VDPWR.n1446 VDPWR.n1445 1.1005
R1146 VDPWR.n1447 VDPWR.n542 1.1005
R1147 VDPWR.n1449 VDPWR.n1448 1.1005
R1148 VDPWR.n1451 VDPWR.n1450 1.1005
R1149 VDPWR.n1452 VDPWR.n506 1.1005
R1150 VDPWR.n1455 VDPWR.n1454 1.1005
R1151 VDPWR.n1457 VDPWR.n1456 1.1005
R1152 VDPWR.n1458 VDPWR.n504 1.1005
R1153 VDPWR.n1461 VDPWR.n1460 1.1005
R1154 VDPWR.n1463 VDPWR.n1462 1.1005
R1155 VDPWR.n1430 VDPWR.n578 0.990109
R1156 VDPWR.n616 VDPWR.n615 0.889051
R1157 VDPWR.n827 VDPWR.n616 0.87634
R1158 VDPWR.n495 VDPWR.n222 0.85094
R1159 VDPWR.n1093 VDPWR.n566 0.797823
R1160 VDPWR.n1094 VDPWR.n566 0.788068
R1161 VDPWR.t1 VDPWR.n526 0.764382
R1162 VDPWR.t33 VDPWR.n517 0.758895
R1163 VDPWR.n1430 VDPWR.n566 0.744196
R1164 VDPWR.n1364 VDPWR.n578 0.711302
R1165 VDPWR.n1369 VDPWR.n578 0.690413
R1166 VDPWR.n947 VDPWR.n946 0.688668
R1167 VDPWR.n946 VDPWR.n707 0.677922
R1168 VDPWR.n1074 VDPWR.n1016 0.6605
R1169 VDPWR.n1075 VDPWR.n1074 0.6605
R1170 VDPWR.n599 VDPWR.t70 0.650654
R1171 VDPWR.n1069 VDPWR.n1052 0.649324
R1172 VDPWR.t62 VDPWR.n551 0.641239
R1173 VDPWR.n1052 VDPWR.n1051 0.632208
R1174 VDPWR.n820 VDPWR.n741 0.608143
R1175 VDPWR.n925 VDPWR.n924 0.608143
R1176 VDPWR.n994 VDPWR.n685 0.607643
R1177 VDPWR.n324 VDPWR.n225 0.605758
R1178 VDPWR.n343 VDPWR.n202 0.599611
R1179 VDPWR.n373 VDPWR.n202 0.588339
R1180 VDPWR.n685 VDPWR.n684 0.587656
R1181 VDPWR.n995 VDPWR.n638 0.586707
R1182 VDPWR.n358 VDPWR.n356 0.58181
R1183 VDPWR.n344 VDPWR.n342 0.5816
R1184 VDPWR.n342 VDPWR.n225 0.580774
R1185 VDPWR.n373 VDPWR.n356 0.576485
R1186 VDPWR.n1070 VDPWR.n1001 0.576245
R1187 VDPWR.n1061 VDPWR.n1060 0.576245
R1188 VDPWR.n530 VDPWR.n529 0.57606
R1189 VDPWR.n1074 VDPWR.n1015 0.574944
R1190 VDPWR.n1430 VDPWR.n616 0.571898
R1191 VDPWR.n1067 VDPWR.n1066 0.570184
R1192 VDPWR.n344 VDPWR.n343 0.569461
R1193 VDPWR.n999 VDPWR.n998 0.567404
R1194 VDPWR.n995 VDPWR.n994 0.567167
R1195 VDPWR.n925 VDPWR.n685 0.567167
R1196 VDPWR.n921 VDPWR.n920 0.564511
R1197 VDPWR.n530 VDPWR.t2 0.562516
R1198 VDPWR.n1156 VDPWR.n1155 0.553457
R1199 VDPWR.n534 VDPWR.n533 0.537639
R1200 VDPWR.n535 VDPWR.n534 0.534022
R1201 VDPWR.n510 VDPWR.n509 0.53228
R1202 VDPWR.n859 VDPWR.n685 0.53225
R1203 VDPWR.n518 VDPWR.n510 0.531768
R1204 VDPWR.n333 VDPWR.n331 0.52944
R1205 VDPWR.n1021 VDPWR.n1011 0.505544
R1206 VDPWR.n1074 VDPWR.n1073 0.501611
R1207 VDPWR.n1019 VDPWR.n1018 0.50119
R1208 VDPWR.n922 VDPWR.n921 0.498997
R1209 VDPWR.n1058 VDPWR.n999 0.49714
R1210 VDPWR.n331 VDPWR.n281 0.464033
R1211 VDPWR.n1465 VDPWR.n502 0.351151
R1212 VDPWR.n331 VDPWR.n330 0.340094
R1213 VDPWR.n1420 VDPWR.n1419 0.315048
R1214 VDPWR.n517 VDPWR.t37 0.311607
R1215 VDPWR.n527 VDPWR.n526 0.296797
R1216 VDPWR.n328 VDPWR.n327 0.283833
R1217 VDPWR.n486 VDPWR.n360 0.274694
R1218 VDPWR.n526 VDPWR.n525 0.273309
R1219 VDPWR.n1018 VDPWR.n1009 0.264118
R1220 VDPWR.n517 VDPWR.t35 0.263611
R1221 VDPWR VDPWR.n1548 0.252613
R1222 VDPWR.n921 VDPWR.n821 0.249073
R1223 VDPWR.n1427 VDPWR.n1012 0.233333
R1224 VDPWR.n597 VDPWR.n545 0.223995
R1225 VDPWR.n1464 VDPWR.n502 0.2205
R1226 VDPWR.n1015 VDPWR.n1009 0.219529
R1227 VDPWR.t33 VDPWR.n510 0.200364
R1228 VDPWR.t33 VDPWR.n534 0.200005
R1229 VDPWR.n832 VDPWR.n621 0.19957
R1230 VDPWR.n837 VDPWR.n621 0.19312
R1231 VDPWR.t64 VDPWR.n1349 0.189157
R1232 VDPWR.n1013 VDPWR.n552 0.188517
R1233 VDPWR.n1155 VDPWR.n190 0.183022
R1234 VDPWR.n1014 VDPWR.n554 0.181217
R1235 VDPWR.n1430 VDPWR.n1429 0.176576
R1236 VDPWR.n636 VDPWR.n634 0.170595
R1237 VDPWR.n917 VDPWR.n916 0.169048
R1238 VDPWR.n596 VDPWR.n546 0.168109
R1239 VDPWR.n340 VDPWR.n233 0.166786
R1240 VDPWR.n266 VDPWR.n265 0.166786
R1241 VDPWR.n401 VDPWR.n382 0.166786
R1242 VDPWR.n442 VDPWR.n367 0.166786
R1243 VDPWR.n450 VDPWR.n364 0.166786
R1244 VDPWR.n597 VDPWR.n546 0.164073
R1245 VDPWR.n1019 VDPWR.n1017 0.161135
R1246 VDPWR.n620 VDPWR.n619 0.158184
R1247 VDPWR.n514 VDPWR.n513 0.157712
R1248 VDPWR.n514 VDPWR.t34 0.157563
R1249 VDPWR.n1014 VDPWR.n553 0.155245
R1250 VDPWR.n1464 VDPWR.n1463 0.154762
R1251 VDPWR.n827 VDPWR.n617 0.152073
R1252 VDPWR.n1073 VDPWR.n1017 0.151694
R1253 VDPWR.n1013 VDPWR.n553 0.147267
R1254 VDPWR.n797 VDPWR.n796 0.147266
R1255 VDPWR.n796 VDPWR.n795 0.147266
R1256 VDPWR.n978 VDPWR.n977 0.145061
R1257 VDPWR.n979 VDPWR.n978 0.145061
R1258 VDPWR.n980 VDPWR.n979 0.145061
R1259 VDPWR.n985 VDPWR.n980 0.145061
R1260 VDPWR.n918 VDPWR.n917 0.141121
R1261 VDPWR.n1346 VDPWR.n575 0.140822
R1262 VDPWR.n332 VDPWR.n233 0.139224
R1263 VDPWR.n272 VDPWR.n271 0.139224
R1264 VDPWR.n267 VDPWR.n266 0.139224
R1265 VDPWR.n264 VDPWR.n263 0.139224
R1266 VDPWR.n393 VDPWR.n386 0.139224
R1267 VDPWR.n394 VDPWR.n382 0.139224
R1268 VDPWR.n434 VDPWR.n370 0.139224
R1269 VDPWR.n435 VDPWR.n367 0.139224
R1270 VDPWR.n443 VDPWR.n364 0.139224
R1271 VDPWR.n333 VDPWR.n332 0.138885
R1272 VDPWR.n272 VDPWR.n232 0.138885
R1273 VDPWR.n271 VDPWR.n270 0.138885
R1274 VDPWR.n265 VDPWR.n264 0.138885
R1275 VDPWR.n263 VDPWR.n192 0.138885
R1276 VDPWR.n394 VDPWR.n393 0.138885
R1277 VDPWR.n402 VDPWR.n401 0.138885
R1278 VDPWR.n435 VDPWR.n434 0.138885
R1279 VDPWR.n443 VDPWR.n442 0.138885
R1280 VDPWR.n490 VDPWR.n450 0.138885
R1281 VDPWR.n495 VDPWR.n225 0.138328
R1282 VDPWR.n837 VDPWR.n622 0.13812
R1283 VDPWR.n495 VDPWR.n202 0.137058
R1284 VDPWR.n1417 VDPWR.n1330 0.134918
R1285 VDPWR.n495 VDPWR.n356 0.130474
R1286 VDPWR.n997 VDPWR.n635 0.129429
R1287 VDPWR.n769 VDPWR.n635 0.126963
R1288 VDPWR.n495 VDPWR.n344 0.126783
R1289 VDPWR.n1079 VDPWR.n554 0.122822
R1290 VDPWR.n996 VDPWR.n637 0.121453
R1291 VDPWR.n1369 VDPWR.n577 0.120877
R1292 VDPWR.n623 VDPWR.n622 0.119072
R1293 VDPWR.n916 VDPWR.n915 0.114009
R1294 VDPWR.n902 VDPWR.n901 0.114009
R1295 VDPWR.n920 VDPWR.n919 0.112845
R1296 VDPWR.n919 VDPWR.n918 0.112845
R1297 VDPWR.n1428 VDPWR.n552 0.112467
R1298 VDPWR.n596 VDPWR.n551 0.112345
R1299 VDPWR.n1071 VDPWR.t51 0.112342
R1300 VDPWR.n998 VDPWR.n634 0.112125
R1301 VDPWR.n270 VDPWR.n269 0.111323
R1302 VDPWR.n269 VDPWR.n268 0.111323
R1303 VDPWR.n268 VDPWR.n267 0.111323
R1304 VDPWR.n386 VDPWR.n385 0.111323
R1305 VDPWR.n402 VDPWR.n379 0.111323
R1306 VDPWR.n410 VDPWR.n379 0.111323
R1307 VDPWR.n411 VDPWR.n410 0.111323
R1308 VDPWR.n411 VDPWR.n377 0.111323
R1309 VDPWR.n419 VDPWR.n377 0.111323
R1310 VDPWR.n420 VDPWR.n419 0.111323
R1311 VDPWR.n426 VDPWR.n425 0.111323
R1312 VDPWR.n426 VDPWR.n370 0.111323
R1313 VDPWR.n490 VDPWR.n489 0.111323
R1314 VDPWR.n648 VDPWR.n637 0.10757
R1315 VDPWR.n648 VDPWR.n647 0.10554
R1316 VDPWR.n1037 VDPWR.n1022 0.104451
R1317 VDPWR.t1 VDPWR.n530 0.101221
R1318 VDPWR.n1430 VDPWR.n598 0.0958832
R1319 VDPWR.n997 VDPWR.n996 0.0908971
R1320 VDPWR.n819 VDPWR.n818 0.0897146
R1321 VDPWR.n1349 VDPWR.n575 0.088832
R1322 VDPWR.n899 VDPWR.n644 0.0859333
R1323 VDPWR.n913 VDPWR.n912 0.085698
R1324 VDPWR.n912 VDPWR.n911 0.085698
R1325 VDPWR.n909 VDPWR.n908 0.085698
R1326 VDPWR.n908 VDPWR.n907 0.085698
R1327 VDPWR.n905 VDPWR.n904 0.085698
R1328 VDPWR.n341 VDPWR.n232 0.0853405
R1329 VDPWR.n1022 VDPWR.n1021 0.0842405
R1330 VDPWR.n923 VDPWR.n819 0.0837188
R1331 VDPWR.n1067 VDPWR.n1054 0.0835606
R1332 VDPWR.n500 VDPWR.n192 0.0834113
R1333 VDPWR.n385 VDPWR.n191 0.0834113
R1334 VDPWR.n1060 VDPWR.n1053 0.0829964
R1335 VDPWR.n512 VDPWR.n508 0.082931
R1336 VDPWR.n513 VDPWR.t36 0.082802
R1337 VDPWR.n341 VDPWR.n340 0.0819459
R1338 VDPWR.n904 VDPWR.n903 0.0818786
R1339 VDPWR.n790 VDPWR.n686 0.08135
R1340 VDPWR.n738 VDPWR.n737 0.08135
R1341 VDPWR.n489 VDPWR.n488 0.078828
R1342 VDPWR.n832 VDPWR.n620 0.0772115
R1343 VDPWR.n1068 VDPWR.n1016 0.0752984
R1344 VDPWR.n1079 VDPWR.n1078 0.0741938
R1345 VDPWR.n1020 VDPWR.n1019 0.0738532
R1346 VDPWR.n1021 VDPWR.n1020 0.071901
R1347 VDPWR.t36 VDPWR.n507 0.0707091
R1348 VDPWR.n1346 VDPWR.t66 0.069971
R1349 VDPWR.n425 VDPWR.n374 0.0696613
R1350 VDPWR.n850 VDPWR.n633 0.0695023
R1351 VDPWR.n1430 VDPWR.t0 0.0676936
R1352 VDPWR.n647 VDPWR.n644 0.0668361
R1353 VDPWR.n1060 VDPWR.n1054 0.066755
R1354 VDPWR.n1068 VDPWR.n1067 0.0660008
R1355 VDPWR.n619 VDPWR.n617 0.0634615
R1356 VDPWR.n485 VDPWR.n484 0.0631263
R1357 VDPWR.n903 VDPWR.n902 0.0616401
R1358 VDPWR.n688 VDPWR.n686 0.0614889
R1359 VDPWR.n800 VDPWR.n738 0.0614889
R1360 VDPWR.n1069 VDPWR.n1053 0.0598278
R1361 VDPWR.n531 VDPWR.n523 0.0578697
R1362 VDPWR.n528 VDPWR.n523 0.0574341
R1363 VDPWR.n1364 VDPWR.n587 0.0570278
R1364 VDPWR.n1018 VDPWR.n1010 0.055276
R1365 VDPWR.n522 VDPWR.n520 0.0547924
R1366 VDPWR.n1011 VDPWR.n1010 0.0535001
R1367 VDPWR.n536 VDPWR.n516 0.0533262
R1368 VDPWR.n1071 VDPWR.n1052 0.0532184
R1369 VDPWR.n516 VDPWR.t34 0.0525623
R1370 VDPWR.n1426 VDPWR.n1425 0.0523571
R1371 VDPWR.n1423 VDPWR.n1422 0.0520952
R1372 VDPWR.n1425 VDPWR.n1424 0.0520952
R1373 VDPWR.n1424 VDPWR.n1423 0.0518333
R1374 VDPWR.n1421 VDPWR.n1420 0.0515714
R1375 VDPWR.n1427 VDPWR.n1426 0.0515714
R1376 VDPWR.n512 VDPWR.n507 0.0514823
R1377 VDPWR.n1422 VDPWR.n1421 0.0505238
R1378 VDPWR.n1375 VDPWR.n577 0.0503933
R1379 VDPWR.n299 VDPWR.n290 0.0492656
R1380 VDPWR.n290 VDPWR.n289 0.0492631
R1381 VDPWR.n915 VDPWR.n828 0.0470972
R1382 VDPWR.n464 VDPWR.n460 0.0465405
R1383 VDPWR.n1361 VDPWR.n587 0.0464363
R1384 VDPWR.n479 VDPWR.n455 0.0453158
R1385 VDPWR.n1243 VDPWR.n1242 0.0450238
R1386 VDPWR.n1458 VDPWR.n1457 0.0450238
R1387 VDPWR.n1452 VDPWR.n1451 0.0450238
R1388 VDPWR.n1448 VDPWR.n1447 0.0450238
R1389 VDPWR.n1447 VDPWR.n1446 0.0450238
R1390 VDPWR.n1446 VDPWR.n543 0.0450238
R1391 VDPWR.n1442 VDPWR.n543 0.0450238
R1392 VDPWR.n1438 VDPWR.n547 0.0450238
R1393 VDPWR.n1390 VDPWR.n1367 0.0450238
R1394 VDPWR.n1391 VDPWR.n1390 0.0450238
R1395 VDPWR.n1392 VDPWR.n1391 0.0450238
R1396 VDPWR.n1392 VDPWR.n1365 0.0450238
R1397 VDPWR.n1396 VDPWR.n1365 0.0450238
R1398 VDPWR.n1404 VDPWR.n1350 0.0450238
R1399 VDPWR.n1405 VDPWR.n1404 0.0450238
R1400 VDPWR.n1418 VDPWR.n1095 0.0450238
R1401 VDPWR.n302 VDPWR.n301 0.0449524
R1402 VDPWR.n319 VDPWR.n312 0.0449323
R1403 VDPWR.n911 VDPWR.n833 0.0448056
R1404 VDPWR.n1160 VDPWR.n1159 0.0447619
R1405 VDPWR.n1160 VDPWR.n1151 0.0447619
R1406 VDPWR.n1164 VDPWR.n1151 0.0447619
R1407 VDPWR.n1165 VDPWR.n1164 0.0447619
R1408 VDPWR.n1166 VDPWR.n1165 0.0447619
R1409 VDPWR.n1166 VDPWR.n1149 0.0447619
R1410 VDPWR.n1170 VDPWR.n1149 0.0447619
R1411 VDPWR.n1171 VDPWR.n1170 0.0447619
R1412 VDPWR.n1172 VDPWR.n1171 0.0447619
R1413 VDPWR.n1172 VDPWR.n1147 0.0447619
R1414 VDPWR.n1176 VDPWR.n1147 0.0447619
R1415 VDPWR.n1177 VDPWR.n1176 0.0447619
R1416 VDPWR.n1178 VDPWR.n1177 0.0447619
R1417 VDPWR.n1178 VDPWR.n1145 0.0447619
R1418 VDPWR.n1182 VDPWR.n1145 0.0447619
R1419 VDPWR.n1183 VDPWR.n1182 0.0447619
R1420 VDPWR.n1184 VDPWR.n1183 0.0447619
R1421 VDPWR.n1184 VDPWR.n1143 0.0447619
R1422 VDPWR.n1188 VDPWR.n1143 0.0447619
R1423 VDPWR.n1189 VDPWR.n1188 0.0447619
R1424 VDPWR.n1190 VDPWR.n1189 0.0447619
R1425 VDPWR.n1190 VDPWR.n1141 0.0447619
R1426 VDPWR.n1194 VDPWR.n1141 0.0447619
R1427 VDPWR.n1195 VDPWR.n1194 0.0447619
R1428 VDPWR.n1196 VDPWR.n1195 0.0447619
R1429 VDPWR.n1196 VDPWR.n1139 0.0447619
R1430 VDPWR.n1200 VDPWR.n1139 0.0447619
R1431 VDPWR.n1201 VDPWR.n1200 0.0447619
R1432 VDPWR.n1202 VDPWR.n1201 0.0447619
R1433 VDPWR.n1202 VDPWR.n1137 0.0447619
R1434 VDPWR.n1206 VDPWR.n1137 0.0447619
R1435 VDPWR.n1207 VDPWR.n1206 0.0447619
R1436 VDPWR.n1208 VDPWR.n1207 0.0447619
R1437 VDPWR.n1208 VDPWR.n1135 0.0447619
R1438 VDPWR.n1212 VDPWR.n1135 0.0447619
R1439 VDPWR.n1213 VDPWR.n1212 0.0447619
R1440 VDPWR.n1214 VDPWR.n1213 0.0447619
R1441 VDPWR.n1214 VDPWR.n1133 0.0447619
R1442 VDPWR.n1218 VDPWR.n1133 0.0447619
R1443 VDPWR.n1219 VDPWR.n1218 0.0447619
R1444 VDPWR.n1220 VDPWR.n1219 0.0447619
R1445 VDPWR.n1220 VDPWR.n1131 0.0447619
R1446 VDPWR.n1224 VDPWR.n1131 0.0447619
R1447 VDPWR.n1225 VDPWR.n1224 0.0447619
R1448 VDPWR.n1226 VDPWR.n1225 0.0447619
R1449 VDPWR.n1226 VDPWR.n1129 0.0447619
R1450 VDPWR.n1230 VDPWR.n1129 0.0447619
R1451 VDPWR.n1231 VDPWR.n1230 0.0447619
R1452 VDPWR.n1232 VDPWR.n1231 0.0447619
R1453 VDPWR.n1232 VDPWR.n1127 0.0447619
R1454 VDPWR.n1236 VDPWR.n1127 0.0447619
R1455 VDPWR.n1237 VDPWR.n1236 0.0447619
R1456 VDPWR.n1238 VDPWR.n1237 0.0447619
R1457 VDPWR.n1238 VDPWR.n1125 0.0447619
R1458 VDPWR.n1242 VDPWR.n1125 0.0447619
R1459 VDPWR.n1244 VDPWR.n1243 0.0447619
R1460 VDPWR.n1244 VDPWR.n1123 0.0447619
R1461 VDPWR.n1249 VDPWR.n1248 0.0445
R1462 VDPWR.n1250 VDPWR.n1121 0.0445
R1463 VDPWR.n1255 VDPWR.n1254 0.0445
R1464 VDPWR.n1256 VDPWR.n1119 0.0445
R1465 VDPWR.n1261 VDPWR.n1260 0.0445
R1466 VDPWR.n1262 VDPWR.n1117 0.0445
R1467 VDPWR.n1267 VDPWR.n1266 0.0445
R1468 VDPWR.n1268 VDPWR.n1115 0.0445
R1469 VDPWR.n1273 VDPWR.n1272 0.0445
R1470 VDPWR.n1274 VDPWR.n1113 0.0445
R1471 VDPWR.n1279 VDPWR.n1278 0.0445
R1472 VDPWR.n1280 VDPWR.n1111 0.0445
R1473 VDPWR.n1285 VDPWR.n1284 0.0445
R1474 VDPWR.n1286 VDPWR.n1109 0.0445
R1475 VDPWR.n1291 VDPWR.n1290 0.0445
R1476 VDPWR.n1292 VDPWR.n1107 0.0445
R1477 VDPWR.n1297 VDPWR.n1296 0.0445
R1478 VDPWR.n1298 VDPWR.n1105 0.0445
R1479 VDPWR.n1303 VDPWR.n1302 0.0445
R1480 VDPWR.n1304 VDPWR.n1103 0.0445
R1481 VDPWR.n1309 VDPWR.n1308 0.0445
R1482 VDPWR.n1310 VDPWR.n1101 0.0445
R1483 VDPWR.n1315 VDPWR.n1314 0.0445
R1484 VDPWR.n1316 VDPWR.n1099 0.0445
R1485 VDPWR.n1321 VDPWR.n1320 0.0445
R1486 VDPWR.n1322 VDPWR.n1097 0.0445
R1487 VDPWR.n1327 VDPWR.n1326 0.0445
R1488 VDPWR.n467 VDPWR.n458 0.0438048
R1489 VDPWR.n1400 VDPWR.n1352 0.0434524
R1490 VDPWR.n905 VDPWR.n838 0.0432778
R1491 VDPWR.n1448 VDPWR.n541 0.0424048
R1492 VDPWR.n420 VDPWR.n374 0.0421613
R1493 VDPWR.n471 VDPWR.n458 0.039481
R1494 VDPWR.t2 VDPWR.n524 0.0394583
R1495 VDPWR.n309 VDPWR.n302 0.0393643
R1496 VDPWR.n1460 VDPWR.n503 0.0392619
R1497 VDPWR.n1441 VDPWR.n1440 0.0392619
R1498 VDPWR.n1414 VDPWR.n1332 0.0392619
R1499 VDPWR.n485 VDPWR.n451 0.0388859
R1500 VDPWR.n472 VDPWR.n455 0.0387621
R1501 VDPWR.n323 VDPWR.n322 0.0386906
R1502 VDPWR.n312 VDPWR.n311 0.0385964
R1503 VDPWR.t37 VDPWR.n520 0.0383695
R1504 VDPWR.n1434 VDPWR.n1433 0.0382143
R1505 VDPWR.n899 VDPWR.n853 0.0379306
R1506 VDPWR.n522 VDPWR.n521 0.0369025
R1507 VDPWR.n802 VDPWR.n801 0.0366718
R1508 VDPWR.n1399 VDPWR.n1398 0.0361191
R1509 VDPWR.n501 VDPWR.n191 0.0356389
R1510 VDPWR.n1459 VDPWR.n1458 0.0353333
R1511 VDPWR.n792 VDPWR.n791 0.0352959
R1512 VDPWR.n1454 VDPWR.n1453 0.0345476
R1513 VDPWR.n636 VDPWR.n633 0.0337839
R1514 VDPWR.n528 VDPWR.n527 0.0337536
R1515 VDPWR.n323 VDPWR.n321 0.0336058
R1516 VDPWR.n1386 VDPWR.n1370 0.0332381
R1517 VDPWR.n1407 VDPWR.n1406 0.0327143
R1518 VDPWR.n990 VDPWR.n989 0.032569
R1519 VDPWR.n931 VDPWR.n930 0.032569
R1520 VDPWR.n1413 VDPWR.n1412 0.0321905
R1521 VDPWR.n619 VDPWR.n618 0.0319786
R1522 VDPWR.n1382 VDPWR.n549 0.0314048
R1523 VDPWR.n535 VDPWR.n515 0.0307914
R1524 VDPWR.n511 VDPWR.n509 0.0307914
R1525 VDPWR.n533 VDPWR.n521 0.0307914
R1526 VDPWR.n529 VDPWR.n531 0.0297354
R1527 VDPWR.n1397 VDPWR.n1396 0.0295714
R1528 VDPWR.n1440 VDPWR.n1439 0.0282619
R1529 VDPWR.n1457 VDPWR.n505 0.028
R1530 VDPWR.n923 VDPWR.n922 0.028
R1531 VDPWR.n538 VDPWR.n535 0.028
R1532 VDPWR.n539 VDPWR.n509 0.028
R1533 VDPWR.n518 VDPWR.n519 0.028
R1534 VDPWR.n525 VDPWR.n524 0.0272361
R1535 VDPWR.n1410 VDPWR.n1347 0.0272143
R1536 VDPWR.n460 VDPWR.n359 0.0267729
R1537 VDPWR.n1385 VDPWR.n1384 0.0266905
R1538 VDPWR.n1384 VDPWR.n1383 0.0261667
R1539 VDPWR.t35 VDPWR.n518 0.0257083
R1540 VDPWR.n1411 VDPWR.n1410 0.025381
R1541 VDPWR.n1073 VDPWR.n1072 0.0246805
R1542 VDPWR.n318 VDPWR.n314 0.0245
R1543 VDPWR.n472 VDPWR.n456 0.0237628
R1544 VDPWR.n465 VDPWR.n459 0.0234305
R1545 VDPWR.n1064 VDPWR.n1008 0.0233942
R1546 VDPWR.n1462 VDPWR.n502 0.0233491
R1547 VDPWR.n846 VDPWR.n627 0.0232586
R1548 VDPWR.n466 VDPWR.n461 0.0230982
R1549 VDPWR.n1328 VDPWR.n1012 0.0230238
R1550 VDPWR.n300 VDPWR.n291 0.0228333
R1551 VDPWR.n309 VDPWR.n303 0.0228333
R1552 VDPWR.n1159 VDPWR.n1158 0.0227619
R1553 VDPWR.n1158 VDPWR.n1157 0.0225
R1554 VDPWR.n614 VDPWR.n605 0.0223103
R1555 VDPWR.n320 VDPWR.n313 0.0221667
R1556 VDPWR.n317 VDPWR.n316 0.0221667
R1557 VDPWR.n481 VDPWR.n478 0.0217689
R1558 VDPWR.n298 VDPWR.n292 0.0215
R1559 VDPWR.n475 VDPWR.n474 0.0214366
R1560 VDPWR.n468 VDPWR.n463 0.0211042
R1561 VDPWR.n1155 VDPWR.n1154 0.0208704
R1562 VDPWR.n844 VDPWR.n632 0.0207299
R1563 VDPWR.n1091 VDPWR.n555 0.0205843
R1564 VDPWR.n310 VDPWR.n304 0.0205
R1565 VDPWR.n482 VDPWR.n453 0.0204396
R1566 VDPWR.n610 VDPWR.n603 0.0204138
R1567 VDPWR.n501 VDPWR.n500 0.0203611
R1568 VDPWR.n1057 VDPWR.n1000 0.0202753
R1569 VDPWR.n1377 VDPWR.n592 0.0202753
R1570 VDPWR.n297 VDPWR.n293 0.0201667
R1571 VDPWR.n1412 VDPWR.n1411 0.0201429
R1572 VDPWR.n786 VDPWR.n670 0.0197838
R1573 VDPWR.n612 VDPWR.n601 0.0197816
R1574 VDPWR.n1372 VDPWR.n594 0.0196573
R1575 VDPWR.n1070 VDPWR.n1069 0.0195972
R1576 VDPWR.n901 VDPWR.n853 0.0195972
R1577 VDPWR.n533 VDPWR.n532 0.0195972
R1578 VDPWR.n849 VDPWR.n629 0.0194655
R1579 VDPWR.n1383 VDPWR.n1382 0.0193571
R1580 VDPWR.n1338 VDPWR.t66 0.0193483
R1581 VDPWR.n787 VDPWR.n669 0.0192432
R1582 VDPWR.n973 VDPWR.n972 0.0191566
R1583 VDPWR.n480 VDPWR.n477 0.0191103
R1584 VDPWR.n470 VDPWR.n457 0.0191103
R1585 VDPWR.n1059 VDPWR.n1001 0.0190393
R1586 VDPWR.n785 VDPWR.n671 0.018973
R1587 VDPWR.n1093 VDPWR.n1092 0.0189363
R1588 VDPWR.n1386 VDPWR.n1385 0.0188333
R1589 VDPWR.n296 VDPWR.n294 0.0188333
R1590 VDPWR.n848 VDPWR.n626 0.0186935
R1591 VDPWR.n969 VDPWR.n968 0.0183614
R1592 VDPWR.n1407 VDPWR.n1347 0.0183095
R1593 VDPWR.n308 VDPWR.n305 0.0181667
R1594 VDPWR.n788 VDPWR.n668 0.0181622
R1595 VDPWR.n595 VDPWR.n550 0.0181124
R1596 VDPWR.n974 VDPWR.n932 0.0180964
R1597 VDPWR.n784 VDPWR.n672 0.0178919
R1598 VDPWR.n608 VDPWR.n607 0.0178851
R1599 VDPWR.n1080 VDPWR.n556 0.0178034
R1600 VDPWR.n1056 VDPWR.n1002 0.0178034
R1601 VDPWR.n483 VDPWR.n454 0.017781
R1602 VDPWR.n608 VDPWR.n606 0.0177453
R1603 VDPWR.n624 VDPWR.n623 0.017569
R1604 VDPWR.n1454 VDPWR.n505 0.0175238
R1605 VDPWR.n301 VDPWR.n295 0.0175
R1606 VDPWR.n1090 VDPWR.n557 0.0174944
R1607 VDPWR.n1345 VDPWR.n574 0.0174944
R1608 VDPWR.n1334 VDPWR.n565 0.0174944
R1609 VDPWR.n789 VDPWR.n667 0.0173514
R1610 VDPWR.n937 VDPWR.n935 0.0173012
R1611 VDPWR.n1439 VDPWR.n1438 0.0172619
R1612 VDPWR.n1376 VDPWR.n590 0.0171854
R1613 VDPWR.n783 VDPWR.n673 0.0170811
R1614 VDPWR.n848 VDPWR.n625 0.0169368
R1615 VDPWR.n851 VDPWR.n628 0.0169368
R1616 VDPWR.n706 VDPWR.n705 0.0169179
R1617 VDPWR.n473 VDPWR.n469 0.016784
R1618 VDPWR.n744 VDPWR.n743 0.0166443
R1619 VDPWR.n1062 VDPWR.n1003 0.0165674
R1620 VDPWR.n1357 VDPWR.n576 0.0165674
R1621 VDPWR.n782 VDPWR.n674 0.0164518
R1622 VDPWR.n479 VDPWR.n476 0.0164517
R1623 VDPWR.n710 VDPWR.n709 0.0163706
R1624 VDPWR.n1337 VDPWR.n573 0.0162584
R1625 VDPWR.n945 VDPWR.n944 0.0161866
R1626 VDPWR.n966 VDPWR.n938 0.0161866
R1627 VDPWR.n746 VDPWR.n745 0.016097
R1628 VDPWR.n609 VDPWR.n604 0.0159885
R1629 VDPWR.n1398 VDPWR.n1397 0.0159524
R1630 VDPWR.n1084 VDPWR.n558 0.0159494
R1631 VDPWR.n1431 VDPWR.n551 0.0159494
R1632 VDPWR.n1342 VDPWR.n567 0.0159494
R1633 VDPWR.n770 VDPWR.n652 0.0159129
R1634 VDPWR.n805 VDPWR.n804 0.0159054
R1635 VDPWR.n612 VDPWR.n602 0.0158487
R1636 VDPWR.n307 VDPWR.n306 0.0158333
R1637 VDPWR.n708 VDPWR.n704 0.0158234
R1638 VDPWR.n1374 VDPWR.n589 0.0156404
R1639 VDPWR.n1353 VDPWR.n586 0.0156404
R1640 VDPWR.n781 VDPWR.n675 0.0156393
R1641 VDPWR.n748 VDPWR.n747 0.0155498
R1642 VDPWR.n950 VDPWR.n949 0.0153657
R1643 VDPWR.n965 VDPWR.n963 0.0153657
R1644 VDPWR.n1087 VDPWR.n564 0.0153315
R1645 VDPWR.n1055 VDPWR.n1004 0.0153315
R1646 VDPWR.n1356 VDPWR.n579 0.0153315
R1647 VDPWR.n317 VDPWR.n315 0.0153164
R1648 VDPWR.n713 VDPWR.n712 0.0152761
R1649 VDPWR.n610 VDPWR.n602 0.0152165
R1650 VDPWR.n803 VDPWR.n799 0.0150946
R1651 VDPWR.n771 VDPWR.n653 0.015092
R1652 VDPWR.n750 VDPWR.n749 0.0150025
R1653 VDPWR.n780 VDPWR.n663 0.0148184
R1654 VDPWR.n711 VDPWR.n703 0.0147289
R1655 VDPWR.n1379 VDPWR.n1378 0.0147135
R1656 VDPWR.n808 VDPWR.n807 0.0145541
R1657 VDPWR.n948 VDPWR.n943 0.0145448
R1658 VDPWR.n964 VDPWR.n939 0.0145448
R1659 VDPWR.n752 VDPWR.n751 0.0144552
R1660 VDPWR.n1339 VDPWR.n572 0.0144045
R1661 VDPWR.n1335 VDPWR.n568 0.0144045
R1662 VDPWR.n466 VDPWR.n462 0.0142762
R1663 VDPWR.n772 VDPWR.n654 0.0142711
R1664 VDPWR.n907 VDPWR.n838 0.01425
R1665 VDPWR.n1434 VDPWR.n549 0.014119
R1666 VDPWR.n1063 VDPWR.n1005 0.0140955
R1667 VDPWR.n1358 VDPWR.n580 0.0140955
R1668 VDPWR.n1343 VDPWR.n1094 0.0140955
R1669 VDPWR.n600 VDPWR.n599 0.014092
R1670 VDPWR.n613 VDPWR.n604 0.014092
R1671 VDPWR.n693 VDPWR.n692 0.0140181
R1672 VDPWR.n806 VDPWR.n798 0.0140135
R1673 VDPWR.n1072 VDPWR.n1016 0.0139861
R1674 VDPWR.n791 VDPWR.n790 0.0139694
R1675 VDPWR.n790 VDPWR.n664 0.0139694
R1676 VDPWR.n800 VDPWR.n739 0.0139694
R1677 VDPWR.n801 VDPWR.n800 0.0139694
R1678 VDPWR.n465 VDPWR.n462 0.0139439
R1679 VDPWR.n716 VDPWR.n715 0.013908
R1680 VDPWR.n1086 VDPWR.n563 0.0137865
R1681 VDPWR.n779 VDPWR.n662 0.0137239
R1682 VDPWR.n953 VDPWR.n952 0.0137239
R1683 VDPWR.n754 VDPWR.n753 0.0136343
R1684 VDPWR.n984 VDPWR.n983 0.013488
R1685 VDPWR.n1375 VDPWR.n1371 0.0134775
R1686 VDPWR.n811 VDPWR.n810 0.013473
R1687 VDPWR.n611 VDPWR.n600 0.0134598
R1688 VDPWR.n646 VDPWR.n631 0.0134598
R1689 VDPWR.n773 VDPWR.n655 0.0134502
R1690 VDPWR.n962 VDPWR.n960 0.0134502
R1691 VDPWR.n714 VDPWR.n702 0.0133607
R1692 VDPWR.n1414 VDPWR.n1413 0.0133333
R1693 VDPWR.n970 VDPWR.n735 0.0133253
R1694 VDPWR.n614 VDPWR.n606 0.01332
R1695 VDPWR.n729 VDPWR.n694 0.0132229
R1696 VDPWR.n971 VDPWR.n736 0.0132229
R1697 VDPWR.n845 VDPWR.n628 0.0131437
R1698 VDPWR.n756 VDPWR.n755 0.0130871
R1699 VDPWR.n318 VDPWR.n315 0.0129831
R1700 VDPWR.n809 VDPWR.n768 0.0129324
R1701 VDPWR.n990 VDPWR.n688 0.0129138
R1702 VDPWR.n688 VDPWR.n687 0.0129138
R1703 VDPWR.n927 VDPWR.n737 0.0129138
R1704 VDPWR.n930 VDPWR.n737 0.0129138
R1705 VDPWR.n778 VDPWR.n661 0.012903
R1706 VDPWR.n951 VDPWR.n942 0.012903
R1707 VDPWR.n1085 VDPWR.n560 0.0128596
R1708 VDPWR.n1354 VDPWR.n584 0.0128596
R1709 VDPWR.n1355 VDPWR.n581 0.0128596
R1710 VDPWR.n1340 VDPWR.n569 0.0128596
R1711 VDPWR.n719 VDPWR.n718 0.0128134
R1712 VDPWR.n1406 VDPWR.n1405 0.0128095
R1713 VDPWR.n1058 VDPWR.n1000 0.0127342
R1714 VDPWR.n1373 VDPWR.n592 0.0127342
R1715 VDPWR.n909 VDPWR.n833 0.0127222
R1716 VDPWR.n774 VDPWR.n656 0.0126294
R1717 VDPWR.n961 VDPWR.n940 0.0126294
R1718 VDPWR.n758 VDPWR.n757 0.0125398
R1719 VDPWR.n284 VDPWR.n281 0.0125
R1720 VDPWR.n289 VDPWR.n281 0.0125
R1721 VDPWR.n324 VDPWR.n220 0.0125
R1722 VDPWR.n325 VDPWR.n324 0.0125
R1723 VDPWR.n488 VDPWR.n487 0.0124637
R1724 VDPWR.n488 VDPWR.n451 0.0124637
R1725 VDPWR.n359 VDPWR.n358 0.0124637
R1726 VDPWR.n697 VDPWR.n696 0.0124277
R1727 VDPWR.n846 VDPWR.n626 0.0123717
R1728 VDPWR.n1370 VDPWR.n1367 0.0122857
R1729 VDPWR.n1075 VDPWR.n1008 0.0122706
R1730 VDPWR.n717 VDPWR.n701 0.0122662
R1731 VDPWR.n1088 VDPWR.n562 0.0122416
R1732 VDPWR.n615 VDPWR.n607 0.0121954
R1733 VDPWR.n814 VDPWR.n813 0.0121216
R1734 VDPWR.n777 VDPWR.n660 0.0120821
R1735 VDPWR.n1044 VDPWR.n1036 0.0120638
R1736 VDPWR.n760 VDPWR.n759 0.0119925
R1737 VDPWR.n1066 VDPWR.n1006 0.0119326
R1738 VDPWR.n956 VDPWR.n955 0.0118085
R1739 VDPWR.n959 VDPWR.n957 0.0118085
R1740 VDPWR.n1373 VDPWR.n593 0.0118073
R1741 VDPWR.n722 VDPWR.n721 0.0117189
R1742 VDPWR.n730 VDPWR.n698 0.0116325
R1743 VDPWR.n793 VDPWR.n669 0.0116299
R1744 VDPWR.n1064 VDPWR.n1007 0.0116236
R1745 VDPWR.n1360 VDPWR.n583 0.0116236
R1746 VDPWR.n812 VDPWR.n767 0.0115811
R1747 VDPWR.n1050 VDPWR.n1023 0.0115638
R1748 VDPWR.n775 VDPWR.n657 0.0115348
R1749 VDPWR.n762 VDPWR.n761 0.0114453
R1750 VDPWR.n1043 VDPWR.n1035 0.0114255
R1751 VDPWR.n1088 VDPWR.n561 0.0113146
R1752 VDPWR.n1081 VDPWR.n559 0.0113146
R1753 VDPWR.n1381 VDPWR.n1380 0.0113146
R1754 VDPWR.n1336 VDPWR.n570 0.0113146
R1755 VDPWR.n776 VDPWR.n659 0.0112612
R1756 VDPWR.n817 VDPWR.n816 0.0111716
R1757 VDPWR.n311 VDPWR.n306 0.0111667
R1758 VDPWR.n1045 VDPWR.n1034 0.011
R1759 VDPWR.n954 VDPWR.n941 0.0109876
R1760 VDPWR.n958 VDPWR.n941 0.0109876
R1761 VDPWR.n1453 VDPWR.n1452 0.0109762
R1762 VDPWR.n842 VDPWR.n625 0.010931
R1763 VDPWR.n1038 VDPWR.n1024 0.0109255
R1764 VDPWR.n988 VDPWR.n986 0.0109231
R1765 VDPWR.n967 VDPWR.n733 0.0109231
R1766 VDPWR.n720 VDPWR.n700 0.010898
R1767 VDPWR.n987 VDPWR.n699 0.010898
R1768 VDPWR.n776 VDPWR.n658 0.0107139
R1769 VDPWR.n1085 VDPWR.n561 0.0106966
R1770 VDPWR.n1340 VDPWR.n570 0.0106966
R1771 VDPWR.n815 VDPWR.n766 0.0106244
R1772 VDPWR.n764 VDPWR.n763 0.0106244
R1773 VDPWR.n847 VDPWR.n624 0.0106149
R1774 VDPWR.n845 VDPWR.n629 0.0106149
R1775 VDPWR.n1049 VDPWR.n1025 0.0105
R1776 VDPWR.n794 VDPWR.n793 0.0104542
R1777 VDPWR.n775 VDPWR.n658 0.0104403
R1778 VDPWR.n913 VDPWR.n828 0.0104306
R1779 VDPWR.n1065 VDPWR.n1007 0.0103876
R1780 VDPWR.n1363 VDPWR.n1362 0.0103876
R1781 VDPWR.n1354 VDPWR.n583 0.0103876
R1782 VDPWR.n1355 VDPWR.n582 0.0103876
R1783 VDPWR.n1042 VDPWR.n1033 0.0103617
R1784 VDPWR.n725 VDPWR.n724 0.0103507
R1785 VDPWR.n725 VDPWR.n723 0.0103507
R1786 VDPWR.n611 VDPWR.n601 0.0102989
R1787 VDPWR.n646 VDPWR.n630 0.0102989
R1788 VDPWR.n1460 VDPWR.n1459 0.0101905
R1789 VDPWR.n956 VDPWR.n954 0.0101667
R1790 VDPWR.n959 VDPWR.n958 0.0101667
R1791 VDPWR.n471 VDPWR.n469 0.0101375
R1792 VDPWR.n766 VDPWR.n765 0.0100771
R1793 VDPWR.n765 VDPWR.n764 0.0100771
R1794 VDPWR.n1046 VDPWR.n1032 0.00993617
R1795 VDPWR.n777 VDPWR.n659 0.00989303
R1796 VDPWR.n1039 VDPWR.n1026 0.0098617
R1797 VDPWR.n724 VDPWR.n700 0.00980348
R1798 VDPWR.n723 VDPWR.n699 0.00980348
R1799 VDPWR.n1360 VDPWR.n1359 0.00976966
R1800 VDPWR.n613 VDPWR.n603 0.00966667
R1801 VDPWR.n817 VDPWR.n815 0.00952985
R1802 VDPWR.n1339 VDPWR.n571 0.00946067
R1803 VDPWR.n1048 VDPWR.n1027 0.00943617
R1804 VDPWR.n1400 VDPWR.n1399 0.00940476
R1805 VDPWR.n850 VDPWR.n632 0.00935057
R1806 VDPWR.n774 VDPWR.n657 0.00934577
R1807 VDPWR.n957 VDPWR.n940 0.00934577
R1808 VDPWR.n988 VDPWR.n987 0.00925622
R1809 VDPWR.n763 VDPWR.n762 0.00925622
R1810 VDPWR.n1041 VDPWR.n1031 0.00919149
R1811 VDPWR.n307 VDPWR.n305 0.00916667
R1812 VDPWR.n1089 VDPWR.n560 0.00915169
R1813 VDPWR.n1063 VDPWR.n1006 0.00915169
R1814 VDPWR.n1362 VDPWR.n584 0.00915169
R1815 VDPWR.n1358 VDPWR.n581 0.00915169
R1816 VDPWR.n1333 VDPWR.n571 0.00915169
R1817 VDPWR.n1335 VDPWR.n569 0.00915169
R1818 VDPWR.n778 VDPWR.n660 0.00907214
R1819 VDPWR.n955 VDPWR.n942 0.00907214
R1820 VDPWR.n722 VDPWR.n720 0.00898259
R1821 VDPWR.n816 VDPWR.n767 0.0089288
R1822 VDPWR.n1040 VDPWR.n1028 0.00879787
R1823 VDPWR.n727 VDPWR.n690 0.00871687
R1824 VDPWR.n761 VDPWR.n760 0.00870895
R1825 VDPWR.n511 VDPWR.n508 0.00863858
R1826 VDPWR.n773 VDPWR.n656 0.00852488
R1827 VDPWR.n962 VDPWR.n961 0.00852488
R1828 VDPWR.n726 VDPWR.n698 0.00845181
R1829 VDPWR.n721 VDPWR.n701 0.00843532
R1830 VDPWR.n814 VDPWR.n812 0.00833784
R1831 VDPWR.n779 VDPWR.n661 0.00825124
R1832 VDPWR.n953 VDPWR.n951 0.00825124
R1833 VDPWR.n1087 VDPWR.n563 0.00822472
R1834 VDPWR.n976 VDPWR.n931 0.00818675
R1835 VDPWR.n759 VDPWR.n758 0.00816169
R1836 VDPWR.n1041 VDPWR.n1030 0.00815957
R1837 VDPWR.n1047 VDPWR.n1030 0.00815957
R1838 VDPWR.n1047 VDPWR.n1029 0.00815957
R1839 VDPWR.n473 VDPWR.n457 0.0081435
R1840 VDPWR.n804 VDPWR.n802 0.00796104
R1841 VDPWR.n1040 VDPWR.n1029 0.00794681
R1842 VDPWR.n1086 VDPWR.n1082 0.00791573
R1843 VDPWR.n1055 VDPWR.n1005 0.00791573
R1844 VDPWR.n1381 VDPWR.n591 0.00791573
R1845 VDPWR.n1374 VDPWR.n588 0.00791573
R1846 VDPWR.n1353 VDPWR.n585 0.00791573
R1847 VDPWR.n1356 VDPWR.n580 0.00791573
R1848 VDPWR.n1046 VDPWR.n1031 0.00791489
R1849 VDPWR.n719 VDPWR.n717 0.00788806
R1850 VDPWR.n536 VDPWR.n515 0.00787469
R1851 VDPWR.n609 VDPWR.n605 0.00777011
R1852 VDPWR.n772 VDPWR.n655 0.00770398
R1853 VDPWR.n757 VDPWR.n756 0.00761443
R1854 VDPWR.n1084 VDPWR.n559 0.00760674
R1855 VDPWR.n1337 VDPWR.n572 0.00760674
R1856 VDPWR.n813 VDPWR.n768 0.00752703
R1857 VDPWR.n952 VDPWR.n943 0.00743035
R1858 VDPWR.n960 VDPWR.n939 0.00743035
R1859 VDPWR.n1042 VDPWR.n1032 0.00738298
R1860 VDPWR.n718 VDPWR.n702 0.0073408
R1861 VDPWR.n1433 VDPWR.n547 0.00730952
R1862 VDPWR.n1048 VDPWR.n1028 0.00730851
R1863 VDPWR.n780 VDPWR.n662 0.00715672
R1864 VDPWR.n483 VDPWR.n476 0.00714653
R1865 VDPWR.n696 VDPWR.n695 0.00712651
R1866 VDPWR.n982 VDPWR.n981 0.00712651
R1867 VDPWR.n727 VDPWR.n689 0.00712651
R1868 VDPWR.n1462 VDPWR.n1461 0.00709483
R1869 VDPWR.n1461 VDPWR.n504 0.00709483
R1870 VDPWR.n1456 VDPWR.n504 0.00709483
R1871 VDPWR.n1456 VDPWR.n1455 0.00709483
R1872 VDPWR.n1455 VDPWR.n506 0.00709483
R1873 VDPWR.n1450 VDPWR.n506 0.00709483
R1874 VDPWR.n1450 VDPWR.n1449 0.00709483
R1875 VDPWR.n1449 VDPWR.n542 0.00709483
R1876 VDPWR.n1445 VDPWR.n542 0.00709483
R1877 VDPWR.n1445 VDPWR.n1444 0.00709483
R1878 VDPWR.n1444 VDPWR.n1443 0.00709483
R1879 VDPWR.n1443 VDPWR.n544 0.00709483
R1880 VDPWR.n1437 VDPWR.n544 0.00709483
R1881 VDPWR.n1437 VDPWR.n1436 0.00709483
R1882 VDPWR.n1436 VDPWR.n1435 0.00709483
R1883 VDPWR.n1435 VDPWR.n548 0.00709483
R1884 VDPWR.n1368 VDPWR.n548 0.00709483
R1885 VDPWR.n1387 VDPWR.n1368 0.00709483
R1886 VDPWR.n1388 VDPWR.n1387 0.00709483
R1887 VDPWR.n1389 VDPWR.n1388 0.00709483
R1888 VDPWR.n1389 VDPWR.n1366 0.00709483
R1889 VDPWR.n1393 VDPWR.n1366 0.00709483
R1890 VDPWR.n1394 VDPWR.n1393 0.00709483
R1891 VDPWR.n1395 VDPWR.n1394 0.00709483
R1892 VDPWR.n1395 VDPWR.n1351 0.00709483
R1893 VDPWR.n1401 VDPWR.n1351 0.00709483
R1894 VDPWR.n1402 VDPWR.n1401 0.00709483
R1895 VDPWR.n1403 VDPWR.n1402 0.00709483
R1896 VDPWR.n1403 VDPWR.n1348 0.00709483
R1897 VDPWR.n1408 VDPWR.n1348 0.00709483
R1898 VDPWR.n1409 VDPWR.n1408 0.00709483
R1899 VDPWR.n1409 VDPWR.n1331 0.00709483
R1900 VDPWR.n1415 VDPWR.n1331 0.00709483
R1901 VDPWR.n1416 VDPWR.n1415 0.00709483
R1902 VDPWR.n1417 VDPWR.n1416 0.00709483
R1903 VDPWR.n1241 VDPWR.n1124 0.00709483
R1904 VDPWR.n1543 VDPWR.n1542 0.00709483
R1905 VDPWR.n1494 VDPWR.n1493 0.00709483
R1906 VDPWR.n755 VDPWR.n754 0.00706716
R1907 VDPWR.n1161 VDPWR.n1152 0.00705603
R1908 VDPWR.n1162 VDPWR.n1161 0.00705603
R1909 VDPWR.n1163 VDPWR.n1162 0.00705603
R1910 VDPWR.n1163 VDPWR.n1150 0.00705603
R1911 VDPWR.n1167 VDPWR.n1150 0.00705603
R1912 VDPWR.n1168 VDPWR.n1167 0.00705603
R1913 VDPWR.n1169 VDPWR.n1168 0.00705603
R1914 VDPWR.n1169 VDPWR.n1148 0.00705603
R1915 VDPWR.n1173 VDPWR.n1148 0.00705603
R1916 VDPWR.n1174 VDPWR.n1173 0.00705603
R1917 VDPWR.n1175 VDPWR.n1174 0.00705603
R1918 VDPWR.n1175 VDPWR.n1146 0.00705603
R1919 VDPWR.n1179 VDPWR.n1146 0.00705603
R1920 VDPWR.n1180 VDPWR.n1179 0.00705603
R1921 VDPWR.n1181 VDPWR.n1180 0.00705603
R1922 VDPWR.n1181 VDPWR.n1144 0.00705603
R1923 VDPWR.n1185 VDPWR.n1144 0.00705603
R1924 VDPWR.n1186 VDPWR.n1185 0.00705603
R1925 VDPWR.n1187 VDPWR.n1186 0.00705603
R1926 VDPWR.n1187 VDPWR.n1142 0.00705603
R1927 VDPWR.n1191 VDPWR.n1142 0.00705603
R1928 VDPWR.n1192 VDPWR.n1191 0.00705603
R1929 VDPWR.n1193 VDPWR.n1192 0.00705603
R1930 VDPWR.n1193 VDPWR.n1140 0.00705603
R1931 VDPWR.n1197 VDPWR.n1140 0.00705603
R1932 VDPWR.n1198 VDPWR.n1197 0.00705603
R1933 VDPWR.n1199 VDPWR.n1198 0.00705603
R1934 VDPWR.n1199 VDPWR.n1138 0.00705603
R1935 VDPWR.n1203 VDPWR.n1138 0.00705603
R1936 VDPWR.n1204 VDPWR.n1203 0.00705603
R1937 VDPWR.n1205 VDPWR.n1204 0.00705603
R1938 VDPWR.n1205 VDPWR.n1136 0.00705603
R1939 VDPWR.n1209 VDPWR.n1136 0.00705603
R1940 VDPWR.n1210 VDPWR.n1209 0.00705603
R1941 VDPWR.n1211 VDPWR.n1210 0.00705603
R1942 VDPWR.n1211 VDPWR.n1134 0.00705603
R1943 VDPWR.n1215 VDPWR.n1134 0.00705603
R1944 VDPWR.n1216 VDPWR.n1215 0.00705603
R1945 VDPWR.n1217 VDPWR.n1216 0.00705603
R1946 VDPWR.n1217 VDPWR.n1132 0.00705603
R1947 VDPWR.n1221 VDPWR.n1132 0.00705603
R1948 VDPWR.n1222 VDPWR.n1221 0.00705603
R1949 VDPWR.n1223 VDPWR.n1222 0.00705603
R1950 VDPWR.n1223 VDPWR.n1130 0.00705603
R1951 VDPWR.n1227 VDPWR.n1130 0.00705603
R1952 VDPWR.n1228 VDPWR.n1227 0.00705603
R1953 VDPWR.n1229 VDPWR.n1228 0.00705603
R1954 VDPWR.n1229 VDPWR.n1128 0.00705603
R1955 VDPWR.n1233 VDPWR.n1128 0.00705603
R1956 VDPWR.n1234 VDPWR.n1233 0.00705603
R1957 VDPWR.n1235 VDPWR.n1234 0.00705603
R1958 VDPWR.n1235 VDPWR.n1126 0.00705603
R1959 VDPWR.n1239 VDPWR.n1126 0.00705603
R1960 VDPWR.n1240 VDPWR.n1239 0.00705603
R1961 VDPWR.n1241 VDPWR.n1240 0.00705603
R1962 VDPWR.n1245 VDPWR.n1124 0.00705603
R1963 VDPWR.n1246 VDPWR.n1245 0.00705603
R1964 VDPWR.n1542 VDPWR.n82 0.00705603
R1965 VDPWR.n1538 VDPWR.n82 0.00705603
R1966 VDPWR.n1538 VDPWR.n1537 0.00705603
R1967 VDPWR.n1537 VDPWR.n87 0.00705603
R1968 VDPWR.n1534 VDPWR.n87 0.00705603
R1969 VDPWR.n1534 VDPWR.n1533 0.00705603
R1970 VDPWR.n1533 VDPWR.n92 0.00705603
R1971 VDPWR.n1530 VDPWR.n92 0.00705603
R1972 VDPWR.n1530 VDPWR.n1529 0.00705603
R1973 VDPWR.n1529 VDPWR.n97 0.00705603
R1974 VDPWR.n1526 VDPWR.n97 0.00705603
R1975 VDPWR.n1526 VDPWR.n1525 0.00705603
R1976 VDPWR.n1525 VDPWR.n102 0.00705603
R1977 VDPWR.n1522 VDPWR.n102 0.00705603
R1978 VDPWR.n1522 VDPWR.n1521 0.00705603
R1979 VDPWR.n1521 VDPWR.n107 0.00705603
R1980 VDPWR.n1518 VDPWR.n107 0.00705603
R1981 VDPWR.n1518 VDPWR.n1517 0.00705603
R1982 VDPWR.n1517 VDPWR.n112 0.00705603
R1983 VDPWR.n1514 VDPWR.n112 0.00705603
R1984 VDPWR.n1514 VDPWR.n1513 0.00705603
R1985 VDPWR.n1513 VDPWR.n117 0.00705603
R1986 VDPWR.n1510 VDPWR.n117 0.00705603
R1987 VDPWR.n1510 VDPWR.n1509 0.00705603
R1988 VDPWR.n1509 VDPWR.n122 0.00705603
R1989 VDPWR.n1506 VDPWR.n122 0.00705603
R1990 VDPWR.n1506 VDPWR.n1505 0.00705603
R1991 VDPWR.n1505 VDPWR.n127 0.00705603
R1992 VDPWR.n1502 VDPWR.n127 0.00705603
R1993 VDPWR.n1502 VDPWR.n1501 0.00705603
R1994 VDPWR.n1501 VDPWR.n132 0.00705603
R1995 VDPWR.n1498 VDPWR.n132 0.00705603
R1996 VDPWR.n1498 VDPWR.n1497 0.00705603
R1997 VDPWR.n1497 VDPWR.n137 0.00705603
R1998 VDPWR.n1494 VDPWR.n137 0.00705603
R1999 VDPWR.n1490 VDPWR.n142 0.00705603
R2000 VDPWR.n1490 VDPWR.n1489 0.00705603
R2001 VDPWR.n1489 VDPWR.n147 0.00705603
R2002 VDPWR.n1486 VDPWR.n147 0.00705603
R2003 VDPWR.n1486 VDPWR.n1485 0.00705603
R2004 VDPWR.n1485 VDPWR.n152 0.00705603
R2005 VDPWR.n1482 VDPWR.n152 0.00705603
R2006 VDPWR.n1482 VDPWR.n1481 0.00705603
R2007 VDPWR.n1481 VDPWR.n157 0.00705603
R2008 VDPWR.n1478 VDPWR.n157 0.00705603
R2009 VDPWR.n1478 VDPWR.n1477 0.00705603
R2010 VDPWR.n1477 VDPWR.n162 0.00705603
R2011 VDPWR.n1474 VDPWR.n162 0.00705603
R2012 VDPWR.n1474 VDPWR.n1473 0.00705603
R2013 VDPWR.n1473 VDPWR.n167 0.00705603
R2014 VDPWR.n1470 VDPWR.n167 0.00705603
R2015 VDPWR.n1470 VDPWR.n1469 0.00705603
R2016 VDPWR.n1469 VDPWR.n171 0.00705603
R2017 VDPWR.n1466 VDPWR.n171 0.00705603
R2018 VDPWR.n1247 VDPWR.n1122 0.00701724
R2019 VDPWR.n1252 VDPWR.n1251 0.00701724
R2020 VDPWR.n1253 VDPWR.n1120 0.00701724
R2021 VDPWR.n1258 VDPWR.n1257 0.00701724
R2022 VDPWR.n1259 VDPWR.n1118 0.00701724
R2023 VDPWR.n1264 VDPWR.n1263 0.00701724
R2024 VDPWR.n1265 VDPWR.n1116 0.00701724
R2025 VDPWR.n1270 VDPWR.n1269 0.00701724
R2026 VDPWR.n1271 VDPWR.n1114 0.00701724
R2027 VDPWR.n1276 VDPWR.n1275 0.00701724
R2028 VDPWR.n1277 VDPWR.n1112 0.00701724
R2029 VDPWR.n1282 VDPWR.n1281 0.00701724
R2030 VDPWR.n1283 VDPWR.n1110 0.00701724
R2031 VDPWR.n1288 VDPWR.n1287 0.00701724
R2032 VDPWR.n1289 VDPWR.n1108 0.00701724
R2033 VDPWR.n1294 VDPWR.n1293 0.00701724
R2034 VDPWR.n1295 VDPWR.n1106 0.00701724
R2035 VDPWR.n1300 VDPWR.n1299 0.00701724
R2036 VDPWR.n1301 VDPWR.n1104 0.00701724
R2037 VDPWR.n1306 VDPWR.n1305 0.00701724
R2038 VDPWR.n1307 VDPWR.n1102 0.00701724
R2039 VDPWR.n1312 VDPWR.n1311 0.00701724
R2040 VDPWR.n1313 VDPWR.n1100 0.00701724
R2041 VDPWR.n1318 VDPWR.n1317 0.00701724
R2042 VDPWR.n1319 VDPWR.n1098 0.00701724
R2043 VDPWR.n1324 VDPWR.n1323 0.00701724
R2044 VDPWR.n1325 VDPWR.n1096 0.00701724
R2045 VDPWR.n1545 VDPWR.n19 0.00755603
R2046 VDPWR.n1543 VDPWR.n9 0.00755603
R2047 VDPWR.n1493 VDPWR.n142 0.00701724
R2048 VDPWR.n1378 VDPWR.n593 0.00698876
R2049 VDPWR.n811 VDPWR.n809 0.00698649
R2050 VDPWR.n976 VDPWR.n975 0.00696385
R2051 VDPWR.n771 VDPWR.n654 0.00688308
R2052 VDPWR.n1039 VDPWR.n1027 0.00688298
R2053 VDPWR.n1548 VDPWR.n35 0.006875
R2054 VDPWR.n1541 VDPWR.n1540 0.006875
R2055 VDPWR.n1492 VDPWR.n138 0.006875
R2056 VDPWR.n1541 VDPWR.n1539 0.0068375
R2057 VDPWR.n1539 VDPWR.n83 0.0068375
R2058 VDPWR.n1536 VDPWR.n83 0.0068375
R2059 VDPWR.n1536 VDPWR.n1535 0.0068375
R2060 VDPWR.n1535 VDPWR.n88 0.0068375
R2061 VDPWR.n1532 VDPWR.n88 0.0068375
R2062 VDPWR.n1532 VDPWR.n1531 0.0068375
R2063 VDPWR.n1531 VDPWR.n93 0.0068375
R2064 VDPWR.n1528 VDPWR.n93 0.0068375
R2065 VDPWR.n1528 VDPWR.n1527 0.0068375
R2066 VDPWR.n1527 VDPWR.n98 0.0068375
R2067 VDPWR.n1524 VDPWR.n98 0.0068375
R2068 VDPWR.n1524 VDPWR.n1523 0.0068375
R2069 VDPWR.n1523 VDPWR.n103 0.0068375
R2070 VDPWR.n1520 VDPWR.n103 0.0068375
R2071 VDPWR.n1520 VDPWR.n1519 0.0068375
R2072 VDPWR.n1519 VDPWR.n108 0.0068375
R2073 VDPWR.n1516 VDPWR.n108 0.0068375
R2074 VDPWR.n1516 VDPWR.n1515 0.0068375
R2075 VDPWR.n1515 VDPWR.n113 0.0068375
R2076 VDPWR.n1512 VDPWR.n113 0.0068375
R2077 VDPWR.n1512 VDPWR.n1511 0.0068375
R2078 VDPWR.n1511 VDPWR.n118 0.0068375
R2079 VDPWR.n1508 VDPWR.n118 0.0068375
R2080 VDPWR.n1508 VDPWR.n1507 0.0068375
R2081 VDPWR.n1507 VDPWR.n123 0.0068375
R2082 VDPWR.n1504 VDPWR.n123 0.0068375
R2083 VDPWR.n1504 VDPWR.n1503 0.0068375
R2084 VDPWR.n1503 VDPWR.n128 0.0068375
R2085 VDPWR.n1500 VDPWR.n128 0.0068375
R2086 VDPWR.n1500 VDPWR.n1499 0.0068375
R2087 VDPWR.n1499 VDPWR.n133 0.0068375
R2088 VDPWR.n1496 VDPWR.n133 0.0068375
R2089 VDPWR.n1496 VDPWR.n1495 0.0068375
R2090 VDPWR.n1495 VDPWR.n138 0.0068375
R2091 VDPWR.n1491 VDPWR.n143 0.0068375
R2092 VDPWR.n1488 VDPWR.n143 0.0068375
R2093 VDPWR.n1488 VDPWR.n1487 0.0068375
R2094 VDPWR.n1487 VDPWR.n148 0.0068375
R2095 VDPWR.n1484 VDPWR.n148 0.0068375
R2096 VDPWR.n1484 VDPWR.n1483 0.0068375
R2097 VDPWR.n1483 VDPWR.n153 0.0068375
R2098 VDPWR.n1480 VDPWR.n153 0.0068375
R2099 VDPWR.n1480 VDPWR.n1479 0.0068375
R2100 VDPWR.n1479 VDPWR.n158 0.0068375
R2101 VDPWR.n1476 VDPWR.n158 0.0068375
R2102 VDPWR.n1476 VDPWR.n1475 0.0068375
R2103 VDPWR.n1475 VDPWR.n163 0.0068375
R2104 VDPWR.n1472 VDPWR.n163 0.0068375
R2105 VDPWR.n1472 VDPWR.n1471 0.0068375
R2106 VDPWR.n1471 VDPWR.n168 0.0068375
R2107 VDPWR.n1468 VDPWR.n168 0.0068375
R2108 VDPWR.n1468 VDPWR.n1467 0.0068375
R2109 VDPWR.n1467 VDPWR.n172 0.0068375
R2110 VDPWR.n308 VDPWR.n304 0.00683333
R2111 VDPWR.n52 VDPWR.n51 0.0073375
R2112 VDPWR.n51 VDPWR.n50 0.007875
R2113 VDPWR.n50 VDPWR.n49 0.0073375
R2114 VDPWR.n66 VDPWR.n65 0.0073375
R2115 VDPWR.n65 VDPWR.n64 0.007875
R2116 VDPWR.n64 VDPWR.n63 0.0073375
R2117 VDPWR.n78 VDPWR.n77 0.0073375
R2118 VDPWR.n77 VDPWR.n76 0.007875
R2119 VDPWR.n76 VDPWR.n75 0.0073375
R2120 VDPWR.n1492 VDPWR.n1491 0.0068
R2121 VDPWR.n716 VDPWR.n714 0.00679353
R2122 VDPWR.n1045 VDPWR.n1033 0.00674468
R2123 VDPWR.n1092 VDPWR.n564 0.00667978
R2124 VDPWR.n1357 VDPWR.n579 0.00667978
R2125 VDPWR.n950 VDPWR.n948 0.00660945
R2126 VDPWR.n965 VDPWR.n964 0.00660945
R2127 VDPWR.n731 VDPWR.n730 0.00659639
R2128 VDPWR.n981 VDPWR.n694 0.00659639
R2129 VDPWR.n810 VDPWR.n798 0.00644595
R2130 VDPWR.n946 VDPWR.n685 0.00643854
R2131 VDPWR.n1376 VDPWR.n589 0.00637079
R2132 VDPWR.n1361 VDPWR.n586 0.00637079
R2133 VDPWR.n781 VDPWR.n663 0.00633582
R2134 VDPWR.n982 VDPWR.n695 0.00633133
R2135 VDPWR.n934 VDPWR.n735 0.00633133
R2136 VDPWR.n933 VDPWR.n736 0.00633133
R2137 VDPWR.n1043 VDPWR.n1034 0.00631915
R2138 VDPWR.n1463 VDPWR.n503 0.0062619
R2139 VDPWR.n1442 VDPWR.n1441 0.0062619
R2140 VDPWR.n1332 VDPWR.n1095 0.0062619
R2141 VDPWR.n753 VDPWR.n752 0.00624627
R2142 VDPWR.n1049 VDPWR.n1026 0.00624468
R2143 VDPWR.n936 VDPWR.n733 0.00616867
R2144 VDPWR.n296 VDPWR.n295 0.00616667
R2145 VDPWR.n177 VDPWR.n27 0.00670259
R2146 VDPWR.n468 VDPWR.n467 0.00614955
R2147 VDPWR.n728 VDPWR.n693 0.00606626
R2148 VDPWR.n770 VDPWR.n653 0.00606219
R2149 VDPWR.n1090 VDPWR.n558 0.0060618
R2150 VDPWR.n1334 VDPWR.n567 0.0060618
R2151 VDPWR.n715 VDPWR.n703 0.00597264
R2152 VDPWR.n808 VDPWR.n806 0.00590541
R2153 VDPWR.n852 VDPWR.n851 0.00587356
R2154 VDPWR.n1038 VDPWR.n1025 0.00581915
R2155 VDPWR.n480 VDPWR.n454 0.00581722
R2156 VDPWR.n475 VDPWR.n470 0.00581722
R2157 VDPWR.n949 VDPWR.n944 0.00578856
R2158 VDPWR.n963 VDPWR.n938 0.00578856
R2159 VDPWR.n1344 VDPWR.n573 0.00575281
R2160 VDPWR.n1342 VDPWR.n1341 0.00575281
R2161 VDPWR.n751 VDPWR.n750 0.005699
R2162 VDPWR.n1044 VDPWR.n1035 0.00568085
R2163 VDPWR.n692 VDPWR.n691 0.00553614
R2164 VDPWR.n782 VDPWR.n675 0.00551492
R2165 VDPWR.n1056 VDPWR.n1003 0.00544382
R2166 VDPWR.n1076 VDPWR.n1015 0.00544382
R2167 VDPWR.t64 VDPWR.n576 0.00544382
R2168 VDPWR.n713 VDPWR.n711 0.00542537
R2169 VDPWR.n807 VDPWR.n799 0.00536486
R2170 VDPWR.n1050 VDPWR.n1024 0.00518085
R2171 VDPWR.n319 VDPWR.n313 0.00516667
R2172 VDPWR.n749 VDPWR.n748 0.00515174
R2173 VDPWR.n28 VDPWR.n18 0.00561638
R2174 VDPWR.n1051 VDPWR.n1036 0.00504255
R2175 VDPWR.n769 VDPWR.n652 0.00496766
R2176 VDPWR.n947 VDPWR.n945 0.00496766
R2177 VDPWR.n967 VDPWR.n966 0.00496766
R2178 VDPWR.n712 VDPWR.n704 0.00487811
R2179 VDPWR.n297 VDPWR.n294 0.00483333
R2180 VDPWR.n321 VDPWR.n316 0.00483333
R2181 VDPWR.n1380 VDPWR.n590 0.00482584
R2182 VDPWR.n1037 VDPWR.n1023 0.00475532
R2183 VDPWR.n983 VDPWR.n690 0.00474096
R2184 VDPWR.n783 VDPWR.n674 0.00464865
R2185 VDPWR.n747 VDPWR.n746 0.00460448
R2186 VDPWR.n805 VDPWR.n803 0.00455405
R2187 VDPWR.n1083 VDPWR.n557 0.00451685
R2188 VDPWR.n1432 VDPWR.n550 0.00451685
R2189 VDPWR.n1343 VDPWR.n565 0.00451685
R2190 VDPWR.n81 VDPWR.n80 0.00450654
R2191 VDPWR.n310 VDPWR.n303 0.0045
R2192 VDPWR.n482 VDPWR.n477 0.00448792
R2193 VDPWR.n4 VDPWR.n3 0.00448255
R2194 VDPWR.n1 VDPWR.n0 0.00445856
R2195 VDPWR.n174 VDPWR.n37 0.00501854
R2196 VDPWR.n38 VDPWR.n176 0.00501854
R2197 VDPWR.n40 VDPWR.n178 0.00501854
R2198 VDPWR.n42 VDPWR.n179 0.00501854
R2199 VDPWR.n44 VDPWR.n180 0.00501854
R2200 VDPWR.n46 VDPWR.n181 0.00501854
R2201 VDPWR.n48 VDPWR.n31 0.00501854
R2202 VDPWR.n33 VDPWR.n32 0.00501854
R2203 VDPWR.n26 VDPWR.n24 0.00501854
R2204 VDPWR.n54 VDPWR.n182 0.00501854
R2205 VDPWR.n56 VDPWR.n183 0.00501854
R2206 VDPWR.n58 VDPWR.n184 0.00501854
R2207 VDPWR.n60 VDPWR.n185 0.00501854
R2208 VDPWR.n62 VDPWR.n21 0.00501854
R2209 VDPWR.n23 VDPWR.n22 0.00501854
R2210 VDPWR.n17 VDPWR.n15 0.00501854
R2211 VDPWR.n68 VDPWR.n186 0.00501854
R2212 VDPWR.n70 VDPWR.n187 0.00501854
R2213 VDPWR.n72 VDPWR.n188 0.00501854
R2214 VDPWR.n74 VDPWR.n12 0.00501854
R2215 VDPWR.n14 VDPWR.n13 0.00501854
R2216 VDPWR.n789 VDPWR.n666 0.00437838
R2217 VDPWR.n710 VDPWR.n708 0.00433085
R2218 VDPWR.n849 VDPWR.n630 0.0042931
R2219 VDPWR.n1059 VDPWR.n1002 0.00420787
R2220 VDPWR.n1363 VDPWR.n585 0.00420787
R2221 VDPWR.n745 VDPWR.n744 0.00405721
R2222 VDPWR.n937 VDPWR.n936 0.00404819
R2223 VDPWR.n1062 VDPWR.n1061 0.00389888
R2224 VDPWR.n1372 VDPWR.n595 0.00389888
R2225 VDPWR.n1338 VDPWR.n574 0.00389888
R2226 VDPWR.n1336 VDPWR.n1333 0.00389888
R2227 VDPWR.n784 VDPWR.n673 0.00383784
R2228 VDPWR.n463 VDPWR.n459 0.00382326
R2229 VDPWR.n464 VDPWR.n461 0.00382326
R2230 VDPWR.n709 VDPWR.n705 0.00378358
R2231 VDPWR.n1465 VDPWR.n5 1.10426
R2232 VDPWR.n2 VDPWR.n190 1.10326
R2233 VDPWR.n1156 VDPWR.n1153 0.00375862
R2234 VDPWR.n1089 VDPWR.n1081 0.00358989
R2235 VDPWR.n788 VDPWR.n667 0.00356757
R2236 VDPWR.n298 VDPWR.n293 0.0035
R2237 VDPWR.n474 VDPWR.n456 0.00349094
R2238 VDPWR.n1061 VDPWR.n1004 0.0032809
R2239 VDPWR.n1377 VDPWR.n591 0.0032809
R2240 VDPWR.n975 VDPWR.n974 0.00325301
R2241 VDPWR.n707 VDPWR.n706 0.00323632
R2242 VDPWR.n818 VDPWR.n743 0.00323632
R2243 VDPWR.n481 VDPWR.n453 0.00315861
R2244 VDPWR.n1451 VDPWR.n541 0.00311905
R2245 VDPWR.n844 VDPWR.n631 0.00302874
R2246 VDPWR.n1091 VDPWR.n556 0.00297191
R2247 VDPWR.n1057 VDPWR.n1001 0.00297191
R2248 VDPWR.n320 VDPWR.n314 0.00283333
R2249 VDPWR.n785 VDPWR.n672 0.00275676
R2250 VDPWR.n847 VDPWR.n842 0.00271264
R2251 VDPWR.n787 VDPWR.n668 0.00248649
R2252 VDPWR.n1082 VDPWR.n562 0.00235393
R2253 VDPWR.n1379 VDPWR.n594 0.00235393
R2254 VDPWR.n1359 VDPWR.n582 0.00235393
R2255 VDPWR.n1341 VDPWR.n568 0.00235393
R2256 VDPWR.n968 VDPWR.n934 0.00219277
R2257 VDPWR.n300 VDPWR.n292 0.00216667
R2258 VDPWR.n486 VDPWR.n357 0.002125
R2259 VDPWR.n448 VDPWR.n447 0.00212499
R2260 VDPWR.n1352 VDPWR.n1350 0.00207143
R2261 VDPWR.n1419 VDPWR.n1418 0.00207143
R2262 VDPWR.n1078 VDPWR.n555 0.00204494
R2263 VDPWR.n1076 VDPWR.n1075 0.00204494
R2264 VDPWR.n27 VDPWR.n1547 0.00199851
R2265 VDPWR.n27 VDPWR.t77 0.00199851
R2266 VDPWR.n18 VDPWR.n1546 0.00199851
R2267 VDPWR.n18 VDPWR.t78 0.00199851
R2268 VDPWR.n8 VDPWR.n1544 0.00199851
R2269 VDPWR.n8 VDPWR.t79 0.00199851
R2270 VDPWR.n792 VDPWR.n666 0.00194594
R2271 VDPWR.n786 VDPWR.n671 0.00194594
R2272 VDPWR.n935 VDPWR.n734 0.00192771
R2273 VDPWR.t3 VDPWR.n222 0.00189997
R2274 VDPWR.n495 VDPWR.n357 0.00187493
R2275 VDPWR.n449 VDPWR.n448 0.00187487
R2276 VDPWR.n484 VDPWR.n478 0.00182931
R2277 VDPWR.n874 VDPWR.n822 0.00181817
R2278 VDPWR.n876 VDPWR.n875 0.00179999
R2279 VDPWR.n277 VDPWR.n216 0.00179999
R2280 VDPWR.n257 VDPWR.n230 0.00179999
R2281 VDPWR.n362 VDPWR.n197 0.00175
R2282 VDPWR.n1083 VDPWR.n1080 0.00173596
R2283 VDPWR.n856 VDPWR.n824 0.00166667
R2284 VDPWR.n855 VDPWR.n825 0.00166667
R2285 VDPWR.n854 VDPWR.n841 0.00166667
R2286 VDPWR.n863 VDPWR.n862 0.00166667
R2287 VDPWR.n880 VDPWR.t43 0.00166667
R2288 VDPWR.n892 VDPWR.n891 0.00166667
R2289 VDPWR.n335 VDPWR.n278 0.00166667
R2290 VDPWR.n339 VDPWR.n338 0.00166667
R2291 VDPWR.n276 VDPWR.n275 0.00166667
R2292 VDPWR.n274 VDPWR.n273 0.00166667
R2293 VDPWR.n240 VDPWR.n239 0.00166667
R2294 VDPWR.n255 VDPWR.n254 0.00166667
R2295 VDPWR.n260 VDPWR.n256 0.00166667
R2296 VDPWR.n259 VDPWR.n258 0.00166667
R2297 VDPWR.n395 VDPWR.n384 0.00166667
R2298 VDPWR.n400 VDPWR.n399 0.00166667
R2299 VDPWR.n403 VDPWR.n381 0.00166667
R2300 VDPWR.n436 VDPWR.n369 0.00166667
R2301 VDPWR.n441 VDPWR.n440 0.00166667
R2302 VDPWR.n444 VDPWR.n366 0.00166667
R2303 VDPWR.n329 VDPWR.n223 0.00166667
R2304 VDPWR.t8 VDPWR.n217 0.00166667
R2305 VDPWR.n234 VDPWR.n215 0.00166667
R2306 VDPWR.n235 VDPWR.n226 0.00166667
R2307 VDPWR.n236 VDPWR.n214 0.00166667
R2308 VDPWR.n241 VDPWR.n227 0.00166667
R2309 VDPWR.t11 VDPWR.n210 0.00166667
R2310 VDPWR.n396 VDPWR.n209 0.00166667
R2311 VDPWR.n380 VDPWR.n347 0.00166667
R2312 VDPWR.n404 VDPWR.n207 0.00166667
R2313 VDPWR.n437 VDPWR.n351 0.00166667
R2314 VDPWR.n365 VDPWR.n198 0.00166667
R2315 VDPWR.n445 VDPWR.n353 0.00166667
R2316 VDPWR.n680 VDPWR.t49 0.00166667
R2317 VDPWR.n327 VDPWR.n221 0.00166667
R2318 VDPWR.n288 VDPWR.n287 0.00166667
R2319 VDPWR.n486 VDPWR.n452 0.00166667
R2320 VDPWR.n731 VDPWR.n697 0.00156024
R2321 VDPWR.n984 VDPWR.n691 0.00156024
R2322 VDPWR.n989 VDPWR.n689 0.00156024
R2323 VDPWR.n969 VDPWR.n734 0.00156024
R2324 VDPWR.n973 VDPWR.n732 0.00156024
R2325 VDPWR.n684 VDPWR.n638 0.00151725
R2326 VDPWR.n684 VDPWR.n651 0.00148273
R2327 VDPWR.n852 VDPWR.n627 0.00144828
R2328 VDPWR.n1066 VDPWR.n1065 0.00142697
R2329 VDPWR.n1432 VDPWR.n1431 0.00142697
R2330 VDPWR.n971 VDPWR.n970 0.00139759
R2331 VDPWR.n972 VDPWR.n933 0.00139759
R2332 VDPWR.n1330 VDPWR.n1329 0.00135345
R2333 VDPWR.n1466 VDPWR.n1465 0.00135345
R2334 VDPWR.n680 VDPWR.n642 0.00133332
R2335 VDPWR.n452 VDPWR.n361 0.00133332
R2336 VDPWR.n495 VDPWR.n221 0.00133332
R2337 VDPWR.n327 VDPWR.n288 0.00133332
R2338 VDPWR.n854 VDPWR.n843 0.00133331
R2339 VDPWR.n855 VDPWR.n826 0.00133331
R2340 VDPWR.n856 VDPWR.n825 0.00133331
R2341 VDPWR.n893 VDPWR.n892 0.00133331
R2342 VDPWR.n864 VDPWR.n863 0.00133331
R2343 VDPWR.n881 VDPWR.n880 0.00133331
R2344 VDPWR.n262 VDPWR.n259 0.00133331
R2345 VDPWR.n335 VDPWR.n334 0.00133331
R2346 VDPWR.n338 VDPWR.n337 0.00133331
R2347 VDPWR.n339 VDPWR.n276 0.00133331
R2348 VDPWR.n275 VDPWR.n274 0.00133331
R2349 VDPWR.n239 VDPWR.n238 0.00133331
R2350 VDPWR.n254 VDPWR.n252 0.00133331
R2351 VDPWR.n260 VDPWR.n255 0.00133331
R2352 VDPWR.n392 VDPWR.n384 0.00133331
R2353 VDPWR.n399 VDPWR.n398 0.00133331
R2354 VDPWR.n400 VDPWR.n381 0.00133331
R2355 VDPWR.n433 VDPWR.n369 0.00133331
R2356 VDPWR.n440 VDPWR.n439 0.00133331
R2357 VDPWR.n441 VDPWR.n366 0.00133331
R2358 VDPWR.n365 VDPWR.n353 0.00133331
R2359 VDPWR.t16 VDPWR.n351 0.00133331
R2360 VDPWR.n383 VDPWR.n347 0.00133331
R2361 VDPWR.t5 VDPWR.n227 0.00133331
R2362 VDPWR.n234 VDPWR.n226 0.00133331
R2363 VDPWR.n279 VDPWR.n217 0.00133331
R2364 VDPWR.n283 VDPWR.n223 0.00133331
R2365 VDPWR.n368 VDPWR.n198 0.00133331
R2366 VDPWR.n380 VDPWR.n207 0.00133331
R2367 VDPWR.t13 VDPWR.n209 0.00133331
R2368 VDPWR.n253 VDPWR.n210 0.00133331
R2369 VDPWR.n235 VDPWR.n214 0.00133331
R2370 VDPWR.n277 VDPWR.n215 0.00133331
R2371 VDPWR.n1153 VDPWR.n1152 0.00131465
R2372 VDPWR.t17 VDPWR.n197 0.00124997
R2373 VDPWR.n875 VDPWR.t42 0.00119997
R2374 VDPWR.t11 VDPWR.n230 0.00119997
R2375 VDPWR.t8 VDPWR.n216 0.00119997
R2376 VDPWR.n874 VDPWR.n821 0.00118179
R2377 VDPWR.n794 VDPWR.n670 0.00113513
R2378 VDPWR.n932 VDPWR.n732 0.00113253
R2379 VDPWR.n1371 VDPWR.n588 0.00111798
R2380 VDPWR.n1345 VDPWR.n1344 0.00111798
R2381 VDPWR.n328 VDPWR.n222 0.00109998
R2382 VDPWR.n1248 VDPWR.n1123 0.00102381
R2383 VDPWR.n1250 VDPWR.n1249 0.00102381
R2384 VDPWR.n1254 VDPWR.n1121 0.00102381
R2385 VDPWR.n1256 VDPWR.n1255 0.00102381
R2386 VDPWR.n1260 VDPWR.n1119 0.00102381
R2387 VDPWR.n1262 VDPWR.n1261 0.00102381
R2388 VDPWR.n1266 VDPWR.n1117 0.00102381
R2389 VDPWR.n1268 VDPWR.n1267 0.00102381
R2390 VDPWR.n1272 VDPWR.n1115 0.00102381
R2391 VDPWR.n1274 VDPWR.n1273 0.00102381
R2392 VDPWR.n1278 VDPWR.n1113 0.00102381
R2393 VDPWR.n1280 VDPWR.n1279 0.00102381
R2394 VDPWR.n1284 VDPWR.n1111 0.00102381
R2395 VDPWR.n1286 VDPWR.n1285 0.00102381
R2396 VDPWR.n1290 VDPWR.n1109 0.00102381
R2397 VDPWR.n1292 VDPWR.n1291 0.00102381
R2398 VDPWR.n1296 VDPWR.n1107 0.00102381
R2399 VDPWR.n1298 VDPWR.n1297 0.00102381
R2400 VDPWR.n1302 VDPWR.n1105 0.00102381
R2401 VDPWR.n1304 VDPWR.n1303 0.00102381
R2402 VDPWR.n1308 VDPWR.n1103 0.00102381
R2403 VDPWR.n1310 VDPWR.n1309 0.00102381
R2404 VDPWR.n1314 VDPWR.n1101 0.00102381
R2405 VDPWR.n1316 VDPWR.n1315 0.00102381
R2406 VDPWR.n1320 VDPWR.n1099 0.00102381
R2407 VDPWR.n1322 VDPWR.n1321 0.00102381
R2408 VDPWR.n1326 VDPWR.n1097 0.00102381
R2409 VDPWR.n1328 VDPWR.n1327 0.00102381
R2410 VDPWR.n995 VDPWR.n645 0.001
R2411 VDPWR.n900 VDPWR.n898 0.001
R2412 VDPWR.n841 VDPWR.n840 0.001
R2413 VDPWR.n906 VDPWR.n839 0.001
R2414 VDPWR.n836 VDPWR.n835 0.001
R2415 VDPWR.n910 VDPWR.n834 0.001
R2416 VDPWR.n831 VDPWR.n830 0.001
R2417 VDPWR.n914 VDPWR.n829 0.001
R2418 VDPWR.n857 VDPWR.n824 0.001
R2419 VDPWR.n858 VDPWR.n823 0.001
R2420 VDPWR.n821 VDPWR.n820 0.001
R2421 VDPWR.n994 VDPWR.n993 0.001
R2422 VDPWR.n992 VDPWR.n665 0.001
R2423 VDPWR.n991 VDPWR.n685 0.001
R2424 VDPWR.n676 VDPWR.n651 0.001
R2425 VDPWR.n677 VDPWR.n650 0.001
R2426 VDPWR.n682 VDPWR.n640 0.001
R2427 VDPWR.n681 VDPWR.n641 0.001
R2428 VDPWR.n896 VDPWR.n895 0.001
R2429 VDPWR.n889 VDPWR.n888 0.001
R2430 VDPWR.n887 VDPWR.n886 0.001
R2431 VDPWR.n885 VDPWR.n884 0.001
R2432 VDPWR.n882 VDPWR.n881 0.001
R2433 VDPWR.n879 VDPWR.n878 0.001
R2434 VDPWR.n869 VDPWR.n868 0.001
R2435 VDPWR.n683 VDPWR.n650 0.001
R2436 VDPWR.n678 VDPWR.n641 0.001
R2437 VDPWR.n679 VDPWR.n642 0.001
R2438 VDPWR.t48 VDPWR.n897 0.001
R2439 VDPWR.n894 VDPWR.n893 0.001
R2440 VDPWR.n891 VDPWR.n890 0.001
R2441 VDPWR.n884 VDPWR.n883 0.001
R2442 VDPWR.n878 VDPWR.n877 0.001
R2443 VDPWR.n873 VDPWR.n872 0.001
R2444 VDPWR.n871 VDPWR.t40 0.001
R2445 VDPWR.n870 VDPWR.n869 0.001
R2446 VDPWR.n866 VDPWR.t38 0.001
R2447 VDPWR.n865 VDPWR.n864 0.001
R2448 VDPWR.n862 VDPWR.n861 0.001
R2449 VDPWR.n860 VDPWR.n859 0.001
R2450 VDPWR.n926 VDPWR.n925 0.001
R2451 VDPWR.n929 VDPWR.n928 0.001
R2452 VDPWR.n742 VDPWR.n740 0.001
R2453 VDPWR.n929 VDPWR.n685 0.001
R2454 VDPWR.n928 VDPWR.n740 0.001
R2455 VDPWR.n992 VDPWR.n991 0.001
R2456 VDPWR.n995 VDPWR.n665 0.001
R2457 VDPWR.n924 VDPWR.n742 0.001
R2458 VDPWR.n820 VDPWR.n742 0.001
R2459 VDPWR.n858 VDPWR.n822 0.001
R2460 VDPWR.n857 VDPWR.n823 0.001
R2461 VDPWR.n829 VDPWR.n826 0.001
R2462 VDPWR.n914 VDPWR.n830 0.001
R2463 VDPWR.n834 VDPWR.n831 0.001
R2464 VDPWR.n910 VDPWR.n835 0.001
R2465 VDPWR.n839 VDPWR.n836 0.001
R2466 VDPWR.n906 VDPWR.n840 0.001
R2467 VDPWR.n898 VDPWR.n843 0.001
R2468 VDPWR.n900 VDPWR.n645 0.001
R2469 VDPWR.n926 VDPWR.n741 0.001
R2470 VDPWR.n859 VDPWR.n741 0.001
R2471 VDPWR.n861 VDPWR.n860 0.001
R2472 VDPWR.t38 VDPWR.n865 0.001
R2473 VDPWR.n867 VDPWR.n866 0.001
R2474 VDPWR.n868 VDPWR.n867 0.001
R2475 VDPWR.t40 VDPWR.n870 0.001
R2476 VDPWR.n872 VDPWR.n871 0.001
R2477 VDPWR.t42 VDPWR.n873 0.001
R2478 VDPWR.n877 VDPWR.n876 0.001
R2479 VDPWR.t43 VDPWR.n879 0.001
R2480 VDPWR.t45 VDPWR.n882 0.001
R2481 VDPWR.n883 VDPWR.t45 0.001
R2482 VDPWR.n886 VDPWR.n885 0.001
R2483 VDPWR.n888 VDPWR.n887 0.001
R2484 VDPWR.t46 VDPWR.n889 0.001
R2485 VDPWR.n890 VDPWR.t46 0.001
R2486 VDPWR.t48 VDPWR.n894 0.001
R2487 VDPWR.n897 VDPWR.n896 0.001
R2488 VDPWR.n895 VDPWR.n643 0.001
R2489 VDPWR.n679 VDPWR.n643 0.001
R2490 VDPWR.n681 VDPWR.t49 0.001
R2491 VDPWR.n678 VDPWR.n649 0.001
R2492 VDPWR.n682 VDPWR.n649 0.001
R2493 VDPWR.n677 VDPWR.n640 0.001
R2494 VDPWR.n683 VDPWR.n639 0.001
R2495 VDPWR.n676 VDPWR.n639 0.001
R2496 VDPWR.n993 VDPWR.n638 0.001
R2497 VDPWR.n330 VDPWR.n280 0.001
R2498 VDPWR.n336 VDPWR.n278 0.001
R2499 VDPWR.n273 VDPWR.n237 0.001
R2500 VDPWR.n242 VDPWR.n240 0.001
R2501 VDPWR.n245 VDPWR.n243 0.001
R2502 VDPWR.n248 VDPWR.n246 0.001
R2503 VDPWR.n251 VDPWR.n249 0.001
R2504 VDPWR.n262 VDPWR.n261 0.001
R2505 VDPWR.n258 VDPWR.n193 0.001
R2506 VDPWR.n499 VDPWR.n498 0.001
R2507 VDPWR.n388 VDPWR.n194 0.001
R2508 VDPWR.n391 VDPWR.n389 0.001
R2509 VDPWR.n397 VDPWR.n395 0.001
R2510 VDPWR.n405 VDPWR.n403 0.001
R2511 VDPWR.n408 VDPWR.n406 0.001
R2512 VDPWR.n409 VDPWR.n378 0.001
R2513 VDPWR.n414 VDPWR.n412 0.001
R2514 VDPWR.n417 VDPWR.n415 0.001
R2515 VDPWR.n418 VDPWR.n376 0.001
R2516 VDPWR.n423 VDPWR.n421 0.001
R2517 VDPWR.n424 VDPWR.n372 0.001
R2518 VDPWR.n429 VDPWR.n427 0.001
R2519 VDPWR.n432 VDPWR.n430 0.001
R2520 VDPWR.n438 VDPWR.n436 0.001
R2521 VDPWR.n446 VDPWR.n444 0.001
R2522 VDPWR.n449 VDPWR.n363 0.001
R2523 VDPWR.n492 VDPWR.n491 0.001
R2524 VDPWR.n494 VDPWR.n493 0.001
R2525 VDPWR.n428 VDPWR.n199 0.001
R2526 VDPWR.n371 VDPWR.n200 0.001
R2527 VDPWR.n422 VDPWR.n201 0.001
R2528 VDPWR.n375 VDPWR.n203 0.001
R2529 VDPWR.n416 VDPWR.n204 0.001
R2530 VDPWR.n413 VDPWR.n205 0.001
R2531 VDPWR.n407 VDPWR.n206 0.001
R2532 VDPWR.n396 VDPWR.n208 0.001
R2533 VDPWR.n387 VDPWR.n195 0.001
R2534 VDPWR.n253 VDPWR.n211 0.001
R2535 VDPWR.n244 VDPWR.n212 0.001
R2536 VDPWR.n236 VDPWR.n213 0.001
R2537 VDPWR.n279 VDPWR.n218 0.001
R2538 VDPWR.t3 VDPWR.n219 0.001
R2539 VDPWR.n493 VDPWR.n355 0.001
R2540 VDPWR.n445 VDPWR.n354 0.001
R2541 VDPWR.n437 VDPWR.n352 0.001
R2542 VDPWR.t16 VDPWR.n350 0.001
R2543 VDPWR.n413 VDPWR.n349 0.001
R2544 VDPWR.n407 VDPWR.n348 0.001
R2545 VDPWR.n390 VDPWR.n346 0.001
R2546 VDPWR.n387 VDPWR.n345 0.001
R2547 VDPWR.n496 VDPWR.n196 0.001
R2548 VDPWR.n257 VDPWR.n231 0.001
R2549 VDPWR.n247 VDPWR.n229 0.001
R2550 VDPWR.n244 VDPWR.n228 0.001
R2551 VDPWR.n283 VDPWR.n224 0.001
R2552 VDPWR.n326 VDPWR.n286 0.001
R2553 VDPWR.n327 VDPWR.n326 0.001
R2554 VDPWR.n330 VDPWR.n285 0.001
R2555 VDPWR.n287 VDPWR.n285 0.001
R2556 VDPWR.n334 VDPWR.n280 0.001
R2557 VDPWR.n337 VDPWR.n336 0.001
R2558 VDPWR.n238 VDPWR.n237 0.001
R2559 VDPWR.n243 VDPWR.n242 0.001
R2560 VDPWR.n246 VDPWR.n245 0.001
R2561 VDPWR.n249 VDPWR.n248 0.001
R2562 VDPWR.n252 VDPWR.n251 0.001
R2563 VDPWR.n261 VDPWR.n256 0.001
R2564 VDPWR.n499 VDPWR.n193 0.001
R2565 VDPWR.n498 VDPWR.n194 0.001
R2566 VDPWR.n389 VDPWR.n388 0.001
R2567 VDPWR.n392 VDPWR.n391 0.001
R2568 VDPWR.n398 VDPWR.n397 0.001
R2569 VDPWR.n406 VDPWR.n405 0.001
R2570 VDPWR.n409 VDPWR.n408 0.001
R2571 VDPWR.n412 VDPWR.n378 0.001
R2572 VDPWR.n415 VDPWR.n414 0.001
R2573 VDPWR.n418 VDPWR.n417 0.001
R2574 VDPWR.n421 VDPWR.n376 0.001
R2575 VDPWR.n424 VDPWR.n423 0.001
R2576 VDPWR.n427 VDPWR.n372 0.001
R2577 VDPWR.n430 VDPWR.n429 0.001
R2578 VDPWR.n433 VDPWR.n432 0.001
R2579 VDPWR.n439 VDPWR.n438 0.001
R2580 VDPWR.n447 VDPWR.n446 0.001
R2581 VDPWR.n491 VDPWR.n363 0.001
R2582 VDPWR.n492 VDPWR.n361 0.001
R2583 VDPWR.n329 VDPWR.n219 0.001
R2584 VDPWR.n282 VDPWR.n224 0.001
R2585 VDPWR.n282 VDPWR.n218 0.001
R2586 VDPWR.t5 VDPWR.n213 0.001
R2587 VDPWR.n241 VDPWR.n212 0.001
R2588 VDPWR.n247 VDPWR.n228 0.001
R2589 VDPWR.n250 VDPWR.n229 0.001
R2590 VDPWR.n250 VDPWR.n211 0.001
R2591 VDPWR.n231 VDPWR.n196 0.001
R2592 VDPWR.n497 VDPWR.n496 0.001
R2593 VDPWR.n497 VDPWR.n195 0.001
R2594 VDPWR.n390 VDPWR.n345 0.001
R2595 VDPWR.t13 VDPWR.n346 0.001
R2596 VDPWR.n383 VDPWR.n208 0.001
R2597 VDPWR.n404 VDPWR.n348 0.001
R2598 VDPWR.t14 VDPWR.n206 0.001
R2599 VDPWR.t14 VDPWR.n349 0.001
R2600 VDPWR.n416 VDPWR.n205 0.001
R2601 VDPWR.n375 VDPWR.n204 0.001
R2602 VDPWR.n422 VDPWR.n203 0.001
R2603 VDPWR.n371 VDPWR.n201 0.001
R2604 VDPWR.n428 VDPWR.n200 0.001
R2605 VDPWR.n431 VDPWR.n199 0.001
R2606 VDPWR.n431 VDPWR.n350 0.001
R2607 VDPWR.n368 VDPWR.n352 0.001
R2608 VDPWR.t17 VDPWR.n354 0.001
R2609 VDPWR.n362 VDPWR.n355 0.001
R2610 VDPWR.n494 VDPWR.n360 0.001
R2611 VDPWR.n299 VDPWR.n291 0.000833333
R2612 VDPWR.n322 VDPWR.n220 0.000833333
R2613 VDPWR.n986 VDPWR.n726 0.00076506
R2614 VDPWR.n729 VDPWR.n728 0.00076506
R2615 VDPWR.n189 VDPWR.n79 0.00105998
R2616 VDPWR.n1247 VDPWR.n1246 0.000577586
R2617 VDPWR.n1251 VDPWR.n1122 0.000577586
R2618 VDPWR.n1253 VDPWR.n1252 0.000577586
R2619 VDPWR.n1257 VDPWR.n1120 0.000577586
R2620 VDPWR.n1259 VDPWR.n1258 0.000577586
R2621 VDPWR.n1263 VDPWR.n1118 0.000577586
R2622 VDPWR.n1265 VDPWR.n1264 0.000577586
R2623 VDPWR.n1269 VDPWR.n1116 0.000577586
R2624 VDPWR.n1271 VDPWR.n1270 0.000577586
R2625 VDPWR.n1275 VDPWR.n1114 0.000577586
R2626 VDPWR.n1277 VDPWR.n1276 0.000577586
R2627 VDPWR.n1281 VDPWR.n1112 0.000577586
R2628 VDPWR.n1283 VDPWR.n1282 0.000577586
R2629 VDPWR.n1287 VDPWR.n1110 0.000577586
R2630 VDPWR.n1289 VDPWR.n1288 0.000577586
R2631 VDPWR.n1293 VDPWR.n1108 0.000577586
R2632 VDPWR.n1295 VDPWR.n1294 0.000577586
R2633 VDPWR.n1299 VDPWR.n1106 0.000577586
R2634 VDPWR.n1301 VDPWR.n1300 0.000577586
R2635 VDPWR.n1305 VDPWR.n1104 0.000577586
R2636 VDPWR.n1307 VDPWR.n1306 0.000577586
R2637 VDPWR.n1311 VDPWR.n1102 0.000577586
R2638 VDPWR.n1313 VDPWR.n1312 0.000577586
R2639 VDPWR.n1317 VDPWR.n1100 0.000577586
R2640 VDPWR.n1319 VDPWR.n1318 0.000577586
R2641 VDPWR.n1323 VDPWR.n1098 0.000577586
R2642 VDPWR.n1325 VDPWR.n1324 0.000577586
R2643 VDPWR.n1329 VDPWR.n1096 0.000577586
R2644 VDPWR.n190 VDPWR.n173 0.00189224
R2645 VDPWR.n173 VDPWR.n175 0.00809483
R2646 VDPWR.n175 VDPWR.n177 0.00809483
R2647 VDPWR.n30 VDPWR.n27 0.00231896
R2648 VDPWR.n30 VDPWR.n29 0.00809483
R2649 VDPWR.n29 VDPWR.n28 0.00809483
R2650 VDPWR.n20 VDPWR.n18 0.00340517
R2651 VDPWR.n20 VDPWR.n19 0.00809483
R2652 VDPWR.n1545 VDPWR.n8 0.000577586
R2653 VDPWR.n10 VDPWR.n8 0.00138793
R2654 VDPWR.n10 VDPWR.n9 0.00809483
R2655 VDPWR.n67 VDPWR.n63 0.00695
R2656 VDPWR.n53 VDPWR.n49 0.00695
R2657 VDPWR.n1540 VDPWR.n75 0.006875
R2658 VDPWR.n78 VDPWR.n73 0.006875
R2659 VDPWR.n73 VDPWR.n71 0.006875
R2660 VDPWR.n71 VDPWR.n69 0.006875
R2661 VDPWR.n69 VDPWR.n67 0.006875
R2662 VDPWR.n66 VDPWR.n61 0.006875
R2663 VDPWR.n61 VDPWR.n59 0.006875
R2664 VDPWR.n59 VDPWR.n57 0.006875
R2665 VDPWR.n57 VDPWR.n55 0.006875
R2666 VDPWR.n55 VDPWR.n53 0.006875
R2667 VDPWR.n52 VDPWR.n47 0.006875
R2668 VDPWR.n47 VDPWR.n45 0.006875
R2669 VDPWR.n45 VDPWR.n43 0.006875
R2670 VDPWR.n43 VDPWR.n41 0.006875
R2671 VDPWR.n41 VDPWR.n39 0.006875
R2672 VDPWR.n39 VDPWR.n34 0.006875
R2673 VDPWR.n36 VDPWR.n34 0.006875
R2674 VDPWR.n36 VDPWR.n35 0.006875
R2675 VDPWR.n26 VDPWR.n25 0.00513849
R2676 VDPWR.n17 VDPWR.n16 0.00513849
R2677 VDPWR.n140 VDPWR.n136 0.00457852
R2678 VDPWR.n169 VDPWR.n3 0.00455453
R2679 VDPWR.n170 VDPWR.n169 0.00455453
R2680 VDPWR.n170 VDPWR.n166 0.00455453
R2681 VDPWR.n164 VDPWR.n166 0.00455453
R2682 VDPWR.n165 VDPWR.n164 0.00455453
R2683 VDPWR.n165 VDPWR.n161 0.00455453
R2684 VDPWR.n159 VDPWR.n161 0.00455453
R2685 VDPWR.n160 VDPWR.n159 0.00455453
R2686 VDPWR.n160 VDPWR.n156 0.00455453
R2687 VDPWR.n154 VDPWR.n156 0.00455453
R2688 VDPWR.n155 VDPWR.n154 0.00455453
R2689 VDPWR.n155 VDPWR.n151 0.00455453
R2690 VDPWR.n149 VDPWR.n151 0.00455453
R2691 VDPWR.n150 VDPWR.n149 0.00455453
R2692 VDPWR.n150 VDPWR.n146 0.00455453
R2693 VDPWR.n144 VDPWR.n146 0.00455453
R2694 VDPWR.n145 VDPWR.n144 0.00455453
R2695 VDPWR.n145 VDPWR.n141 0.00455453
R2696 VDPWR.n139 VDPWR.n141 0.00455453
R2697 VDPWR.n134 VDPWR.n136 0.00455453
R2698 VDPWR.n135 VDPWR.n134 0.00455453
R2699 VDPWR.n135 VDPWR.n131 0.00455453
R2700 VDPWR.n129 VDPWR.n131 0.00455453
R2701 VDPWR.n130 VDPWR.n129 0.00455453
R2702 VDPWR.n130 VDPWR.n126 0.00455453
R2703 VDPWR.n124 VDPWR.n126 0.00455453
R2704 VDPWR.n125 VDPWR.n124 0.00455453
R2705 VDPWR.n125 VDPWR.n121 0.00455453
R2706 VDPWR.n119 VDPWR.n121 0.00455453
R2707 VDPWR.n120 VDPWR.n119 0.00455453
R2708 VDPWR.n120 VDPWR.n116 0.00455453
R2709 VDPWR.n114 VDPWR.n116 0.00455453
R2710 VDPWR.n115 VDPWR.n114 0.00455453
R2711 VDPWR.n115 VDPWR.n111 0.00455453
R2712 VDPWR.n109 VDPWR.n111 0.00455453
R2713 VDPWR.n110 VDPWR.n109 0.00455453
R2714 VDPWR.n110 VDPWR.n106 0.00455453
R2715 VDPWR.n104 VDPWR.n106 0.00455453
R2716 VDPWR.n105 VDPWR.n104 0.00455453
R2717 VDPWR.n105 VDPWR.n101 0.00455453
R2718 VDPWR.n99 VDPWR.n101 0.00455453
R2719 VDPWR.n100 VDPWR.n99 0.00455453
R2720 VDPWR.n100 VDPWR.n96 0.00455453
R2721 VDPWR.n94 VDPWR.n96 0.00455453
R2722 VDPWR.n95 VDPWR.n94 0.00455453
R2723 VDPWR.n95 VDPWR.n91 0.00455453
R2724 VDPWR.n89 VDPWR.n91 0.00455453
R2725 VDPWR.n90 VDPWR.n89 0.00455453
R2726 VDPWR.n90 VDPWR.n86 0.00455453
R2727 VDPWR.n84 VDPWR.n86 0.00455453
R2728 VDPWR.n85 VDPWR.n84 0.00455453
R2729 VDPWR.n85 VDPWR.n6 0.00455453
R2730 VDPWR.n81 VDPWR.n7 0.00455453
R2731 VDPWR.n140 VDPWR.n139 0.00453053
R2732 VDPWR.n79 VDPWR.n80 0.00509051
R2733 VDPWR.n7 VDPWR.n6 0.0046265
R2734 VDPWR.n33 VDPWR.n25 0.00457852
R2735 VDPWR.n23 VDPWR.n16 0.00457852
R2736 VDPWR.n14 VDPWR.n11 0.00457852
R2737 VDPWR.n189 VDPWR.n11 0.00457852
R2738 VDPWR.n1548 VDPWR.n2 2.20304
R2739 VGND.n1202 VGND.n1201 1.06209e+06
R2740 VGND.n1202 VGND.n45 319714
R2741 VGND.n44 VGND.n45 38443.3
R2742 VGND.n1201 VGND.n27 10563.4
R2743 VGND.n1199 VGND.n22 4780.04
R2744 VGND.n1201 VGND.n13 3886.06
R2745 VGND.t58 VGND.n1203 2027.48
R2746 VGND.n1203 VGND.n1202 1503.17
R2747 VGND.n21 VGND.n45 388.517
R2748 VGND.n2 VGND.n43 383.466
R2749 VGND.n13 VGND.n1199 83.6902
R2750 VGND.n1027 VGND.n899 79.2375
R2751 VGND.n1208 VGND.n1023 78.6705
R2752 VGND.n1028 VGND.n900 77.57
R2753 VGND.n1207 VGND.n1022 76.4694
R2754 VGND.n1922 VGND.n429 54.5772
R2755 VGND.n1196 VGND.n1195 51.6187
R2756 VGND.n1054 VGND.n925 50.8121
R2757 VGND.n1089 VGND.n961 50.1064
R2758 VGND.n1124 VGND.n997 50.1064
R2759 VGND.n1125 VGND.n998 50.1064
R2760 VGND.n1055 VGND.n926 49.4006
R2761 VGND.n1052 VGND.n924 49.4006
R2762 VGND.n1091 VGND.n960 49.373
R2763 VGND.n1126 VGND.n999 48.6949
R2764 VGND.n1088 VGND.n963 48.3354
R2765 VGND.n1056 VGND.n927 47.9892
R2766 VGND.n1051 VGND.n923 47.9892
R2767 VGND.n1206 VGND.n1021 47.6297
R2768 VGND.n1092 VGND.n959 47.2835
R2769 VGND.n1122 VGND.n995 47.2835
R2770 VGND.n1127 VGND.n1000 47.2835
R2771 VGND.n1087 VGND.n964 46.5778
R2772 VGND.n1057 VGND.n928 46.5778
R2773 VGND.n1050 VGND.n922 46.5778
R2774 VGND.n1093 VGND.n958 45.8721
R2775 VGND.n1121 VGND.n994 45.8721
R2776 VGND.n1128 VGND.n1001 45.8721
R2777 VGND.n1086 VGND.n965 45.1663
R2778 VGND.n1058 VGND.n929 45.1663
R2779 VGND.n1049 VGND.n921 45.1663
R2780 VGND.n1094 VGND.n957 44.4606
R2781 VGND.n1120 VGND.n993 44.4606
R2782 VGND.n1129 VGND.n1002 44.4606
R2783 VGND.n1085 VGND.n966 43.7549
R2784 VGND.n1119 VGND.n992 43.7549
R2785 VGND.n1059 VGND.n930 43.7549
R2786 VGND.n1048 VGND.n920 43.7549
R2787 VGND.n1095 VGND.n956 43.0492
R2788 VGND.n1060 VGND.n931 43.0492
R2789 VGND.n1033 VGND.n905 42.6897
R2790 VGND.n1084 VGND.n967 42.3435
R2791 VGND.n1118 VGND.n991 42.3435
R2792 VGND.n1123 VGND.t53 42.3435
R2793 VGND.n1047 VGND.n919 42.3435
R2794 VGND.n1200 VGND.n901 42.3435
R2795 VGND.n1145 VGND.n1017 41.9839
R2796 VGND.n1096 VGND.n955 41.6378
R2797 VGND.n1061 VGND.n932 41.6378
R2798 VGND.n1131 VGND.n1004 41.6378
R2799 VGND.n1034 VGND.n906 41.2782
R2800 VGND.n1083 VGND.n968 40.932
R2801 VGND.n1117 VGND.n990 40.932
R2802 VGND.n1046 VGND.n918 40.932
R2803 VGND.n1144 VGND.n1016 40.5725
R2804 VGND.n1153 VGND.n1032 40.5725
R2805 VGND.n1097 VGND.n954 40.2263
R2806 VGND.n1132 VGND.n1005 40.2263
R2807 VGND.n1035 VGND.n907 39.8668
R2808 VGND.n1082 VGND.n969 39.5206
R2809 VGND.n1116 VGND.n989 39.5206
R2810 VGND.n1045 VGND.n917 39.5206
R2811 VGND.n1143 VGND.n1015 39.1611
R2812 VGND.n1098 VGND.n953 38.8149
R2813 VGND.n1063 VGND.n934 38.8149
R2814 VGND.n1133 VGND.n1006 38.8149
R2815 VGND.n1036 VGND.n908 38.4554
R2816 VGND.n1081 VGND.n970 38.1092
R2817 VGND.n1115 VGND.n988 38.1092
R2818 VGND.n1044 VGND.n916 38.1092
R2819 VGND.n1142 VGND.n1014 37.7496
R2820 VGND.n1099 VGND.n952 37.4035
R2821 VGND.n1064 VGND.n935 37.4035
R2822 VGND.n1134 VGND.n1007 37.4035
R2823 VGND.n1037 VGND.n909 37.0439
R2824 VGND.n1203 VGND.n1162 37.0375
R2825 VGND.n1080 VGND.n971 36.6977
R2826 VGND.n1114 VGND.n987 36.6977
R2827 VGND.n1043 VGND.n915 36.6977
R2828 VGND.n1141 VGND.n1013 36.3382
R2829 VGND.n1152 VGND.n1147 36.3382
R2830 VGND.n1100 VGND.n951 35.992
R2831 VGND.n1065 VGND.n936 35.992
R2832 VGND.n1135 VGND.n1008 35.992
R2833 VGND.n1038 VGND.n910 35.6325
R2834 VGND.n1079 VGND.n972 35.2863
R2835 VGND.n1113 VGND.n986 35.2863
R2836 VGND.n1042 VGND.n914 35.2863
R2837 VGND.n1140 VGND.n1012 34.9268
R2838 VGND.n1101 VGND.n950 34.5806
R2839 VGND.n1066 VGND.n937 34.5806
R2840 VGND.t8 VGND.n933 34.5806
R2841 VGND.n1136 VGND.n1009 34.5806
R2842 VGND.n1039 VGND.n911 34.2211
R2843 VGND.n1078 VGND.n973 33.8749
R2844 VGND.n1112 VGND.n985 33.8749
R2845 VGND.n1041 VGND.n913 33.8749
R2846 VGND.n1139 VGND.n1011 33.5154
R2847 VGND.t48 VGND.n949 33.1692
R2848 VGND.n1067 VGND.n938 33.1692
R2849 VGND.n1137 VGND.n1010 33.1692
R2850 VGND.n1077 VGND.n974 32.4634
R2851 VGND.n1111 VGND.n984 32.4634
R2852 VGND.n1151 VGND.n1031 32.1039
R2853 VGND.n1102 VGND.n948 31.7577
R2854 VGND.n1068 VGND.n939 31.7577
R2855 VGND.t54 VGND.n1003 31.7577
R2856 VGND.n1076 VGND.n975 31.052
R2857 VGND.n1110 VGND.n983 31.052
R2858 VGND.n1103 VGND.n947 30.3463
R2859 VGND.n1069 VGND.n940 30.3463
R2860 VGND.n1075 VGND.n976 29.6406
R2861 VGND.n1109 VGND.n982 29.6406
R2862 VGND.n1104 VGND.n946 28.9349
R2863 VGND.n1070 VGND.n941 28.9349
R2864 VGND.n33 VGND.n13 2.98071
R2865 VGND.n1074 VGND.n977 28.2292
R2866 VGND.n1108 VGND.n981 28.2292
R2867 VGND.n1205 VGND.n1204 27.8696
R2868 VGND.n1105 VGND.n945 27.5234
R2869 VGND.n1071 VGND.n942 27.5234
R2870 VGND.n1146 VGND.t56 27.1639
R2871 VGND.n1073 VGND.n978 26.8177
R2872 VGND.n1107 VGND.n980 26.8177
R2873 VGND.n1106 VGND.n944 26.112
R2874 VGND.n1072 VGND.n943 26.112
R2875 VGND.n1106 VGND.n979 25.4063
R2876 VGND.n1072 VGND.n979 25.4063
R2877 VGND.n1073 VGND.n944 24.7006
R2878 VGND.n1107 VGND.n943 24.7006
R2879 VGND.n1105 VGND.n978 23.9949
R2880 VGND.n1071 VGND.n980 23.9949
R2881 VGND.n1150 VGND.n1030 23.6353
R2882 VGND.n1108 VGND.n942 23.2891
R2883 VGND.n1150 VGND.n902 23.2891
R2884 VGND.n1104 VGND.n977 22.5834
R2885 VGND.n1075 VGND.n946 21.8777
R2886 VGND.n1109 VGND.n941 21.8777
R2887 VGND.n1103 VGND.n976 21.172
R2888 VGND.n1069 VGND.n982 21.172
R2889 VGND.n1076 VGND.n947 20.4663
R2890 VGND.n1110 VGND.n940 20.4663
R2891 VGND.n1102 VGND.n975 19.7606
R2892 VGND.t50 VGND.n981 19.7606
R2893 VGND.n1068 VGND.n983 19.7606
R2894 VGND.n1077 VGND.n948 19.0548
R2895 VGND.n1111 VGND.n939 19.0548
R2896 VGND.t55 VGND.n912 19.0548
R2897 VGND.t48 VGND.n974 18.3491
R2898 VGND.n1067 VGND.n984 18.3491
R2899 VGND.n1204 VGND.n1020 18.3491
R2900 VGND.n1078 VGND.n949 17.6434
R2901 VGND.n1162 VGND.n945 17.6434
R2902 VGND.n1112 VGND.n938 17.6434
R2903 VGND.n1041 VGND.n1010 17.6434
R2904 VGND.n1137 VGND.n912 17.6434
R2905 VGND.n1040 VGND.n1011 17.6434
R2906 VGND.n1139 VGND.n911 17.2839
R2907 VGND.t13 VGND.n33 18.5454
R2908 VGND.n1198 VGND.t7 17.0005
R2909 VGND.t7 VGND.n1170 17.0005
R2910 VGND.t7 VGND.n1171 17.0005
R2911 VGND.t7 VGND.n1172 17.0005
R2912 VGND.t7 VGND.n1197 17.0005
R2913 VGND.t3 VGND.n1 0.572784
R2914 VGND.n2 VGND.n35 0.150511
R2915 VGND.n1223 VGND.n1027 17.0005
R2916 VGND.n14 VGND.n13 0.489519
R2917 VGND.n1429 VGND.n21 17.0005
R2918 VGND.n1427 VGND.n21 17.0005
R2919 VGND.n762 VGND.n21 17.0005
R2920 VGND.n814 VGND.n21 17.0005
R2921 VGND.n765 VGND.n21 17.0005
R2922 VGND.n816 VGND.n21 17.0005
R2923 VGND.n768 VGND.n21 17.0005
R2924 VGND.n806 VGND.n21 17.0005
R2925 VGND.n771 VGND.n21 17.0005
R2926 VGND.n804 VGND.n21 17.0005
R2927 VGND.n10 VGND.n21 17.0005
R2928 VGND.n773 VGND.n21 17.0005
R2929 VGND.n1412 VGND.n21 17.0005
R2930 VGND.n776 VGND.n21 17.0005
R2931 VGND.n797 VGND.n21 17.0005
R2932 VGND.n779 VGND.n21 17.0005
R2933 VGND.n795 VGND.n21 17.0005
R2934 VGND.n782 VGND.n21 17.0005
R2935 VGND.n787 VGND.n21 17.0005
R2936 VGND.n785 VGND.n21 17.0005
R2937 VGND.n1424 VGND.n21 17.0005
R2938 VGND.n21 VGND.n48 17.0005
R2939 VGND.n1433 VGND.n21 17.0005
R2940 VGND.n1435 VGND.n21 17.0005
R2941 VGND.n1437 VGND.n21 17.0005
R2942 VGND.n1439 VGND.n21 17.0005
R2943 VGND.n1441 VGND.n21 17.0005
R2944 VGND.n1443 VGND.n21 17.0005
R2945 VGND.n1445 VGND.n21 17.0005
R2946 VGND.n1447 VGND.n21 17.0005
R2947 VGND.n1449 VGND.n21 17.0005
R2948 VGND.n1451 VGND.n21 17.0005
R2949 VGND.n1453 VGND.n21 17.0005
R2950 VGND.n1455 VGND.n21 17.0005
R2951 VGND.n1457 VGND.n21 17.0005
R2952 VGND.n1459 VGND.n21 17.0005
R2953 VGND.n1461 VGND.n21 17.0005
R2954 VGND.n1463 VGND.n21 17.0005
R2955 VGND.n1465 VGND.n21 17.0005
R2956 VGND.n1467 VGND.n21 17.0005
R2957 VGND.n761 VGND.n21 17.0005
R2958 VGND.t42 VGND.n1432 17.0005
R2959 VGND.t42 VGND.n1434 17.0005
R2960 VGND.t42 VGND.n1436 17.0005
R2961 VGND.t42 VGND.n1438 17.0005
R2962 VGND.t42 VGND.n1440 17.0005
R2963 VGND.t42 VGND.n1442 17.0005
R2964 VGND.t42 VGND.n1444 17.0005
R2965 VGND.t42 VGND.n1446 17.0005
R2966 VGND.t42 VGND.n1448 17.0005
R2967 VGND.t42 VGND.n1450 17.0005
R2968 VGND.t42 VGND.n1454 17.0005
R2969 VGND.t42 VGND.n1456 17.0005
R2970 VGND.t42 VGND.n1458 17.0005
R2971 VGND.t42 VGND.n1460 17.0005
R2972 VGND.t42 VGND.n1462 17.0005
R2973 VGND.t42 VGND.n1464 17.0005
R2974 VGND.t42 VGND.n1466 17.0005
R2975 VGND.t42 VGND.n1468 17.0005
R2976 VGND.n1469 VGND.t42 17.0005
R2977 VGND.n1426 VGND.t45 17.0005
R2978 VGND.t45 VGND.n763 17.0005
R2979 VGND.t45 VGND.n764 17.0005
R2980 VGND.t45 VGND.n766 17.0005
R2981 VGND.t45 VGND.n767 17.0005
R2982 VGND.t45 VGND.n769 17.0005
R2983 VGND.t45 VGND.n770 17.0005
R2984 VGND.t45 VGND.n772 17.0005
R2985 VGND.t45 VGND.n9 8.49235
R2986 VGND.t45 VGND.n8 17.0005
R2987 VGND.t45 VGND.n774 17.0005
R2988 VGND.t45 VGND.n775 17.0005
R2989 VGND.t45 VGND.n777 17.0005
R2990 VGND.t45 VGND.n778 17.0005
R2991 VGND.t45 VGND.n780 17.0005
R2992 VGND.t45 VGND.n781 17.0005
R2993 VGND.t45 VGND.n783 17.0005
R2994 VGND.t45 VGND.n784 17.0005
R2995 VGND.t45 VGND.n786 17.0005
R2996 VGND.t45 VGND.n1425 17.0005
R2997 VGND.n27 VGND.n1150 17.0005
R2998 VGND.n1204 VGND.n27 17.0005
R2999 VGND.n27 VGND.n1151 17.0005
R3000 VGND.n27 VGND.n1152 17.0005
R3001 VGND.n27 VGND.n1153 17.0005
R3002 VGND.n27 VGND.n1154 17.0005
R3003 VGND.n27 VGND.n1161 17.0005
R3004 VGND.n1223 VGND.n897 17.0005
R3005 VGND.n42 VGND.n40 4.23676
R3006 VGND.n40 VGND.n961 17.0005
R3007 VGND.t57 VGND.n1214 17.0005
R3008 VGND.t57 VGND.n1217 17.0005
R3009 VGND.t57 VGND.n1218 17.0005
R3010 VGND.t57 VGND.n1216 17.0005
R3011 VGND.t57 VGND.n1219 17.0005
R3012 VGND.t57 VGND.n1215 17.0005
R3013 VGND.n1220 VGND.t57 17.0005
R3014 VGND.t47 VGND.n888 17.0005
R3015 VGND.n895 VGND.t47 17.0005
R3016 VGND.t47 VGND.n891 17.0005
R3017 VGND.t47 VGND.n892 17.0005
R3018 VGND.t47 VGND.n890 17.0005
R3019 VGND.t47 VGND.n893 17.0005
R3020 VGND.t47 VGND.n894 17.0005
R3021 VGND.n1101 VGND.n973 16.9377
R3022 VGND.n1066 VGND.n985 16.9377
R3023 VGND.n1136 VGND.n913 16.9377
R3024 VGND.n1039 VGND.n1012 16.5782
R3025 VGND.n1079 VGND.n950 16.232
R3026 VGND.n1113 VGND.n937 16.232
R3027 VGND.n1042 VGND.n1009 16.232
R3028 VGND.t56 VGND.n1018 16.232
R3029 VGND.n1140 VGND.n910 15.8724
R3030 VGND.n1100 VGND.n972 15.5263
R3031 VGND.n1065 VGND.n986 15.5263
R3032 VGND.n1135 VGND.n914 15.5263
R3033 VGND.n35 VGND.n1199 17.5179
R3034 VGND.n1038 VGND.n1013 15.1667
R3035 VGND.n1080 VGND.n951 14.8205
R3036 VGND.n1114 VGND.n936 14.8205
R3037 VGND.n1043 VGND.n1008 14.8205
R3038 VGND.n1141 VGND.n909 14.461
R3039 VGND.n1099 VGND.n971 14.1148
R3040 VGND.n1064 VGND.n987 14.1148
R3041 VGND.n1134 VGND.n915 14.1148
R3042 VGND.n1040 VGND.t55 14.1148
R3043 VGND.t5 VGND.n3 15.0042
R3044 VGND.n1037 VGND.n1014 13.7553
R3045 VGND.n1081 VGND.n952 13.4091
R3046 VGND.n1115 VGND.n935 13.4091
R3047 VGND.n1044 VGND.n1007 13.4091
R3048 VGND.n1151 VGND.n903 13.4091
R3049 VGND.n1222 VGND.n37 13.2197
R3050 VGND.n1142 VGND.n908 13.0496
R3051 VGND.n1098 VGND.n970 12.7034
R3052 VGND.n1063 VGND.n988 12.7034
R3053 VGND.n1133 VGND.n916 12.7034
R3054 VGND.n49 VGND.n1224 12.5165
R3055 VGND.n1036 VGND.n1015 12.3439
R3056 VGND.n1082 VGND.n953 11.9977
R3057 VGND.n1045 VGND.n1006 11.9977
R3058 VGND.n1143 VGND.n907 11.6381
R3059 VGND.n1097 VGND.n969 11.292
R3060 VGND.n1062 VGND.n989 11.292
R3061 VGND.n1130 VGND.t54 11.292
R3062 VGND.n1132 VGND.n917 11.292
R3063 VGND.n1035 VGND.n1016 10.9324
R3064 VGND.n1083 VGND.n954 10.5862
R3065 VGND.n1117 VGND.n933 10.5862
R3066 VGND.n1046 VGND.n1005 10.5862
R3067 VGND.n1144 VGND.n906 10.2267
R3068 VGND.n1096 VGND.n968 9.88053
R3069 VGND.n1061 VGND.n990 9.88053
R3070 VGND.n1131 VGND.n918 9.88053
R3071 VGND.t0 VGND.n27 4912.1
R3072 VGND.n1034 VGND.n1017 9.52099
R3073 VGND.n21 VGND.t41 4.71857
R3074 VGND.n1200 VGND.n1029 9.33811
R3075 VGND.n1084 VGND.n955 9.17481
R3076 VGND.n1118 VGND.n932 9.17481
R3077 VGND.n1047 VGND.n1004 9.17481
R3078 VGND.n54 VGND.n53 0.698988
R3079 VGND.n170 VGND.n52 1.09157
R3080 VGND.n169 VGND.n168 1.09157
R3081 VGND.n167 VGND.n166 1.09157
R3082 VGND.n165 VGND.n164 1.09157
R3083 VGND.n132 VGND.n131 0.857366
R3084 VGND.n134 VGND.n133 1.09157
R3085 VGND.n136 VGND.n135 1.09157
R3086 VGND.n138 VGND.n137 1.09157
R3087 VGND.n140 VGND.n139 1.09157
R3088 VGND.n142 VGND.n141 1.09157
R3089 VGND.n144 VGND.n143 1.09157
R3090 VGND.n146 VGND.n145 1.09157
R3091 VGND.n148 VGND.n147 1.09157
R3092 VGND.n150 VGND.n149 1.09157
R3093 VGND.n152 VGND.n151 1.09157
R3094 VGND.n154 VGND.n153 2.23712
R3095 VGND.n130 VGND.n155 0.261556
R3096 VGND.n129 VGND.n130 0.179445
R3097 VGND.n216 VGND.n58 1.47643
R3098 VGND.n215 VGND.n213 1.09157
R3099 VGND.n214 VGND.n211 1.09157
R3100 VGND.n212 VGND.n209 1.09157
R3101 VGND.n210 VGND.n207 1.09157
R3102 VGND.n208 VGND.n205 1.09157
R3103 VGND.n206 VGND.n203 1.09157
R3104 VGND.n204 VGND.n201 1.09157
R3105 VGND.n202 VGND.n199 1.09157
R3106 VGND.n200 VGND.n197 1.09157
R3107 VGND.n198 VGND.n195 1.09157
R3108 VGND.n196 VGND.n193 1.09157
R3109 VGND.n194 VGND.n191 1.09157
R3110 VGND.n192 VGND.n189 1.09157
R3111 VGND.n190 VGND.n187 1.09157
R3112 VGND.n188 VGND.n185 1.09157
R3113 VGND.n186 VGND.n183 1.09157
R3114 VGND.n184 VGND.n181 1.09157
R3115 VGND.n182 VGND.n179 1.09157
R3116 VGND.n180 VGND.n177 1.09157
R3117 VGND.n178 VGND.n175 1.09157
R3118 VGND.n176 VGND.n171 1.09157
R3119 VGND.n174 VGND.n173 0.503451
R3120 VGND.n1190 VGND.n1189 9.0005
R3121 VGND.n1190 VGND.n1178 9.0005
R3122 VGND.n1180 VGND.n1178 9.0005
R3123 VGND.n1187 VGND.n1178 9.0005
R3124 VGND.n11 VGND.n1166 9.0005
R3125 VGND.t19 VGND.n65 1.3026
R3126 VGND.n2032 VGND.t19 9.0005
R3127 VGND.n66 VGND.n397 0.0134064
R3128 VGND.t21 VGND.n1996 9.0005
R3129 VGND.n1997 VGND.t21 9.0005
R3130 VGND.t21 VGND.n406 9.0005
R3131 VGND.t21 VGND.n404 9.0005
R3132 VGND.n159 VGND.n1955 2.25851
R3133 VGND.n1956 VGND.t23 9.0005
R3134 VGND.n55 VGND.n419 2.22244
R3135 VGND.n47 VGND.n2 0.0834049
R3136 VGND.n1166 VGND.n13 8.51119
R3137 VGND.t14 VGND.n13 8.501
R3138 VGND.n20 VGND.n21 0.0143079
R3139 VGND.n1195 VGND.n20 0.565894
R3140 VGND.n29 VGND.n5 0.0123391
R3141 VGND.n29 VGND.n28 0.00364024
R3142 VGND.n1195 VGND.n29 0.629139
R3143 VGND.n19 VGND.n23 0.0100815
R3144 VGND.n1195 VGND.n7 1.13314
R3145 VGND.n22 VGND.n21 0.911051
R3146 VGND.n41 VGND.n40 0.00313575
R3147 VGND.n1223 VGND.n1210 8.50094
R3148 VGND.n1223 VGND.n1211 8.50094
R3149 VGND.n1223 VGND.n1212 8.50094
R3150 VGND.n1223 VGND.n1213 8.50094
R3151 VGND.n1169 VGND.n2 8.5009
R3152 VGND.n1173 VGND.n2 8.5009
R3153 VGND.n40 VGND.n884 8.50088
R3154 VGND.n40 VGND.n887 8.50088
R3155 VGND.n40 VGND.n885 8.50088
R3156 VGND.n40 VGND.n886 8.50088
R3157 VGND.n40 VGND.n882 8.50088
R3158 VGND.n27 VGND.n1148 8.50081
R3159 VGND.n1223 VGND.n1090 8.50081
R3160 VGND.n2 VGND.n1194 8.5008
R3161 VGND.n1164 VGND.n13 8.50062
R3162 VGND.n40 VGND.n896 8.50062
R3163 VGND.n40 VGND.n962 8.50062
R3164 VGND.n1182 VGND.n2 8.5005
R3165 VGND.n46 VGND.n2 0.0824236
R3166 VGND.t2 VGND.n3 74.5908
R3167 VGND.n1223 VGND.n1221 8.5005
R3168 VGND.n40 VGND.n899 8.5005
R3169 VGND.n40 VGND.n1023 8.5005
R3170 VGND.n40 VGND.n900 8.5005
R3171 VGND.n40 VGND.n1022 8.5005
R3172 VGND.n27 VGND.n51 8.5005
R3173 VGND.n27 VGND.n50 8.5005
R3174 VGND.n1223 VGND.t48 8.5005
R3175 VGND.n1225 VGND.n40 8.5005
R3176 VGND.n1223 VGND.n1089 8.5005
R3177 VGND.n1223 VGND.n1091 8.5005
R3178 VGND.n1223 VGND.n1088 8.5005
R3179 VGND.n1223 VGND.n1092 8.5005
R3180 VGND.n1223 VGND.n1087 8.5005
R3181 VGND.n1223 VGND.n1093 8.5005
R3182 VGND.n1223 VGND.n1086 8.5005
R3183 VGND.n1223 VGND.n1094 8.5005
R3184 VGND.n1223 VGND.n1085 8.5005
R3185 VGND.n1223 VGND.n1095 8.5005
R3186 VGND.n1223 VGND.n1084 8.5005
R3187 VGND.n1223 VGND.n1096 8.5005
R3188 VGND.n1223 VGND.n1083 8.5005
R3189 VGND.n1223 VGND.n1097 8.5005
R3190 VGND.n1223 VGND.n1082 8.5005
R3191 VGND.n1223 VGND.n1098 8.5005
R3192 VGND.n1223 VGND.n1081 8.5005
R3193 VGND.n1223 VGND.n1099 8.5005
R3194 VGND.n1223 VGND.n1080 8.5005
R3195 VGND.n1223 VGND.n1100 8.5005
R3196 VGND.n1223 VGND.n1079 8.5005
R3197 VGND.n1223 VGND.n1101 8.5005
R3198 VGND.n1223 VGND.n1078 8.5005
R3199 VGND.n1223 VGND.n1077 8.5005
R3200 VGND.n1223 VGND.n1102 8.5005
R3201 VGND.n1223 VGND.n1076 8.5005
R3202 VGND.n1223 VGND.n1103 8.5005
R3203 VGND.n1223 VGND.n1075 8.5005
R3204 VGND.n1223 VGND.n1104 8.5005
R3205 VGND.n1223 VGND.n1074 8.5005
R3206 VGND.n1223 VGND.n1105 8.5005
R3207 VGND.n1223 VGND.n1073 8.5005
R3208 VGND.n1223 VGND.n1106 8.5005
R3209 VGND.n1223 VGND.n1072 8.5005
R3210 VGND.n1223 VGND.n1107 8.5005
R3211 VGND.n1223 VGND.n1071 8.5005
R3212 VGND.n1223 VGND.n1108 8.5005
R3213 VGND.n1223 VGND.n1070 8.5005
R3214 VGND.n1223 VGND.n1109 8.5005
R3215 VGND.n1223 VGND.n1069 8.5005
R3216 VGND.n1223 VGND.n1110 8.5005
R3217 VGND.n1223 VGND.n1068 8.5005
R3218 VGND.n1223 VGND.n1111 8.5005
R3219 VGND.n1223 VGND.n1067 8.5005
R3220 VGND.n1223 VGND.n1112 8.5005
R3221 VGND.n1223 VGND.n1066 8.5005
R3222 VGND.n1223 VGND.n1113 8.5005
R3223 VGND.n1223 VGND.n1065 8.5005
R3224 VGND.n1223 VGND.n1114 8.5005
R3225 VGND.n1223 VGND.n1064 8.5005
R3226 VGND.n1223 VGND.n1115 8.5005
R3227 VGND.n1223 VGND.n1063 8.5005
R3228 VGND.n1223 VGND.n1116 8.5005
R3229 VGND.n1223 VGND.n1062 8.5005
R3230 VGND.n1223 VGND.n1117 8.5005
R3231 VGND.n1223 VGND.n1061 8.5005
R3232 VGND.n1223 VGND.n1118 8.5005
R3233 VGND.n1223 VGND.n1060 8.5005
R3234 VGND.n1223 VGND.n1119 8.5005
R3235 VGND.n1223 VGND.n1059 8.5005
R3236 VGND.n1223 VGND.n1120 8.5005
R3237 VGND.n1223 VGND.n1058 8.5005
R3238 VGND.n1223 VGND.n1121 8.5005
R3239 VGND.n1223 VGND.n1057 8.5005
R3240 VGND.n1223 VGND.n1122 8.5005
R3241 VGND.n1223 VGND.n1056 8.5005
R3242 VGND.n1223 VGND.n1123 8.5005
R3243 VGND.n1223 VGND.n1055 8.5005
R3244 VGND.n1223 VGND.n1124 8.5005
R3245 VGND.n1223 VGND.n1054 8.5005
R3246 VGND.n1223 VGND.n1125 8.5005
R3247 VGND.n1223 VGND.n1052 8.5005
R3248 VGND.n1223 VGND.n1126 8.5005
R3249 VGND.n1223 VGND.n1051 8.5005
R3250 VGND.n1223 VGND.n1127 8.5005
R3251 VGND.n1223 VGND.n1050 8.5005
R3252 VGND.n1223 VGND.n1128 8.5005
R3253 VGND.n1223 VGND.n1049 8.5005
R3254 VGND.n1223 VGND.n1129 8.5005
R3255 VGND.n1223 VGND.n1048 8.5005
R3256 VGND.n1223 VGND.n1130 8.5005
R3257 VGND.n1223 VGND.n1047 8.5005
R3258 VGND.n1223 VGND.n1131 8.5005
R3259 VGND.n1223 VGND.n1046 8.5005
R3260 VGND.n1223 VGND.n1132 8.5005
R3261 VGND.n1223 VGND.n1045 8.5005
R3262 VGND.n1223 VGND.n1133 8.5005
R3263 VGND.n1223 VGND.n1044 8.5005
R3264 VGND.n1223 VGND.n1134 8.5005
R3265 VGND.n1223 VGND.n1043 8.5005
R3266 VGND.n1223 VGND.n1135 8.5005
R3267 VGND.n1223 VGND.n1042 8.5005
R3268 VGND.n1223 VGND.n1136 8.5005
R3269 VGND.n1223 VGND.n1041 8.5005
R3270 VGND.n1223 VGND.n1137 8.5005
R3271 VGND.n1223 VGND.n1040 8.5005
R3272 VGND.n1025 VGND.n40 8.5005
R3273 VGND.n40 VGND.n901 8.5005
R3274 VGND.n40 VGND.n1021 8.5005
R3275 VGND.n40 VGND.n902 8.5005
R3276 VGND.n40 VGND.n1020 8.5005
R3277 VGND.n40 VGND.n903 8.5005
R3278 VGND.n40 VGND.n1019 8.5005
R3279 VGND.n40 VGND.n904 8.5005
R3280 VGND.n40 VGND.n1018 8.5005
R3281 VGND.n40 VGND.n905 8.5005
R3282 VGND.n40 VGND.n1017 8.5005
R3283 VGND.n40 VGND.n906 8.5005
R3284 VGND.n40 VGND.n1016 8.5005
R3285 VGND.n40 VGND.n907 8.5005
R3286 VGND.n40 VGND.n1015 8.5005
R3287 VGND.n40 VGND.n908 8.5005
R3288 VGND.n40 VGND.n1014 8.5005
R3289 VGND.n40 VGND.n909 8.5005
R3290 VGND.n40 VGND.n1013 8.5005
R3291 VGND.n40 VGND.n910 8.5005
R3292 VGND.n40 VGND.n1012 8.5005
R3293 VGND.n40 VGND.n911 8.5005
R3294 VGND.n40 VGND.n1011 8.5005
R3295 VGND.n40 VGND.n912 8.5005
R3296 VGND.n40 VGND.n1010 8.5005
R3297 VGND.n40 VGND.n913 8.5005
R3298 VGND.n40 VGND.n1009 8.5005
R3299 VGND.n40 VGND.n914 8.5005
R3300 VGND.n40 VGND.n1008 8.5005
R3301 VGND.n40 VGND.n915 8.5005
R3302 VGND.n40 VGND.n1007 8.5005
R3303 VGND.n40 VGND.n916 8.5005
R3304 VGND.n40 VGND.n1006 8.5005
R3305 VGND.n40 VGND.n917 8.5005
R3306 VGND.n40 VGND.n1005 8.5005
R3307 VGND.n40 VGND.n918 8.5005
R3308 VGND.n40 VGND.n1004 8.5005
R3309 VGND.n40 VGND.n919 8.5005
R3310 VGND.n40 VGND.n1003 8.5005
R3311 VGND.n40 VGND.n920 8.5005
R3312 VGND.n40 VGND.n1002 8.5005
R3313 VGND.n40 VGND.n921 8.5005
R3314 VGND.n40 VGND.n1001 8.5005
R3315 VGND.n40 VGND.n922 8.5005
R3316 VGND.n40 VGND.n1000 8.5005
R3317 VGND.n40 VGND.n923 8.5005
R3318 VGND.n40 VGND.n999 8.5005
R3319 VGND.n40 VGND.n924 8.5005
R3320 VGND.n40 VGND.n998 8.5005
R3321 VGND.n40 VGND.n925 8.5005
R3322 VGND.n40 VGND.n997 8.5005
R3323 VGND.n40 VGND.n926 8.5005
R3324 VGND.n40 VGND.n996 8.5005
R3325 VGND.n40 VGND.n927 8.5005
R3326 VGND.n40 VGND.n995 8.5005
R3327 VGND.n40 VGND.n928 8.5005
R3328 VGND.n40 VGND.n994 8.5005
R3329 VGND.n40 VGND.n929 8.5005
R3330 VGND.n40 VGND.n993 8.5005
R3331 VGND.n40 VGND.n930 8.5005
R3332 VGND.n40 VGND.n992 8.5005
R3333 VGND.n40 VGND.n931 8.5005
R3334 VGND.n40 VGND.n991 8.5005
R3335 VGND.n40 VGND.n932 8.5005
R3336 VGND.n40 VGND.n990 8.5005
R3337 VGND.n40 VGND.n933 8.5005
R3338 VGND.n40 VGND.n989 8.5005
R3339 VGND.n40 VGND.n934 8.5005
R3340 VGND.n40 VGND.n988 8.5005
R3341 VGND.n40 VGND.n935 8.5005
R3342 VGND.n40 VGND.n987 8.5005
R3343 VGND.n40 VGND.n936 8.5005
R3344 VGND.n40 VGND.n986 8.5005
R3345 VGND.n40 VGND.n937 8.5005
R3346 VGND.n40 VGND.n985 8.5005
R3347 VGND.n40 VGND.n938 8.5005
R3348 VGND.n40 VGND.n984 8.5005
R3349 VGND.n40 VGND.n939 8.5005
R3350 VGND.n40 VGND.n983 8.5005
R3351 VGND.n40 VGND.n940 8.5005
R3352 VGND.n40 VGND.n982 8.5005
R3353 VGND.n40 VGND.n941 8.5005
R3354 VGND.n40 VGND.n981 8.5005
R3355 VGND.n40 VGND.n942 8.5005
R3356 VGND.n40 VGND.n980 8.5005
R3357 VGND.n40 VGND.n943 8.5005
R3358 VGND.n40 VGND.n979 8.5005
R3359 VGND.n40 VGND.n944 8.5005
R3360 VGND.n40 VGND.n978 8.5005
R3361 VGND.n40 VGND.n945 8.5005
R3362 VGND.n40 VGND.n977 8.5005
R3363 VGND.n40 VGND.n946 8.5005
R3364 VGND.n40 VGND.n976 8.5005
R3365 VGND.n40 VGND.n947 8.5005
R3366 VGND.n40 VGND.n975 8.5005
R3367 VGND.n40 VGND.n948 8.5005
R3368 VGND.n40 VGND.n974 8.5005
R3369 VGND.n40 VGND.n949 8.5005
R3370 VGND.n40 VGND.n973 8.5005
R3371 VGND.n40 VGND.n950 8.5005
R3372 VGND.n40 VGND.n972 8.5005
R3373 VGND.n40 VGND.n951 8.5005
R3374 VGND.n40 VGND.n971 8.5005
R3375 VGND.n40 VGND.n952 8.5005
R3376 VGND.n40 VGND.n970 8.5005
R3377 VGND.n40 VGND.n953 8.5005
R3378 VGND.n40 VGND.n969 8.5005
R3379 VGND.n40 VGND.n954 8.5005
R3380 VGND.n40 VGND.n968 8.5005
R3381 VGND.n40 VGND.n955 8.5005
R3382 VGND.n40 VGND.n967 8.5005
R3383 VGND.n40 VGND.n956 8.5005
R3384 VGND.n40 VGND.n966 8.5005
R3385 VGND.n40 VGND.n957 8.5005
R3386 VGND.n40 VGND.n965 8.5005
R3387 VGND.n40 VGND.n958 8.5005
R3388 VGND.n40 VGND.n964 8.5005
R3389 VGND.n40 VGND.n959 8.5005
R3390 VGND.n27 VGND.n1157 8.50043
R3391 VGND.n27 VGND.n1156 8.50024
R3392 VGND.n27 VGND.n1149 8.49966
R3393 VGND.n27 VGND.n1160 8.49966
R3394 VGND.t42 VGND.n1452 8.49218
R3395 VGND.n1471 VGND.n21 8.48299
R3396 VGND.n1469 VGND.n24 1.0653
R3397 VGND.n24 VGND.n6 2.0419
R3398 VGND.n6 VGND.n5 0.655735
R3399 VGND.n6 VGND.n30 1.95616
R3400 VGND.n30 VGND.t43 1.13708
R3401 VGND.n31 VGND.n23 1.07517
R3402 VGND.t43 VGND.n31 0.612881
R3403 VGND.n16 VGND.n15 0.79354
R3404 VGND.n31 VGND.n16 1.60381
R3405 VGND.n34 VGND.n7 1.97162
R3406 VGND.n16 VGND.n34 1.34797
R3407 VGND.n1095 VGND.n967 8.4691
R3408 VGND.n1060 VGND.n991 8.4691
R3409 VGND.n1130 VGND.n919 8.4691
R3410 VGND.n1152 VGND.n1019 8.4691
R3411 VGND.n1223 VGND.n1206 8.32816
R3412 VGND.n1223 VGND.n1030 8.32816
R3413 VGND.n1223 VGND.n1205 8.32816
R3414 VGND.n1223 VGND.n1031 8.32816
R3415 VGND.n1223 VGND.n1147 8.32816
R3416 VGND.n1223 VGND.n1032 8.32816
R3417 VGND.n1223 VGND.n1146 8.32816
R3418 VGND.n1223 VGND.n1033 8.32816
R3419 VGND.n1223 VGND.n1145 8.32816
R3420 VGND.n1223 VGND.n1034 8.32816
R3421 VGND.n1223 VGND.n1144 8.32816
R3422 VGND.n1223 VGND.n1035 8.32816
R3423 VGND.n1223 VGND.n1143 8.32816
R3424 VGND.n1223 VGND.n1036 8.32816
R3425 VGND.n1223 VGND.n1142 8.32816
R3426 VGND.n1223 VGND.n1037 8.32816
R3427 VGND.n1223 VGND.n1141 8.32816
R3428 VGND.n1223 VGND.n1038 8.32816
R3429 VGND.n1223 VGND.n1140 8.32816
R3430 VGND.n1223 VGND.n1039 8.32816
R3431 VGND.n1223 VGND.n1139 8.32816
R3432 VGND.n40 VGND.n963 8.32816
R3433 VGND.n1223 VGND.n1208 8.2345
R3434 VGND.n1223 VGND.n1028 8.2345
R3435 VGND.n1223 VGND.n1207 8.2345
R3436 VGND.n1223 VGND.n1029 8.2345
R3437 VGND.t15 VGND.n27 5.37949
R3438 VGND.n40 VGND.n960 8.16221
R3439 VGND.n4 VGND.t6 34.3905
R3440 VGND.n2 VGND.n3 0.00105912
R3441 VGND.n2 VGND.n4 0.00731971
R3442 VGND.n1119 VGND.n931 7.76338
R3443 VGND.n1048 VGND.n1003 7.76338
R3444 VGND.n1146 VGND.n904 7.40385
R3445 VGND.n44 VGND.t11 7.14576
R3446 VGND.n1053 VGND.n998 7.07581
R3447 VGND.n1094 VGND.n966 7.05766
R3448 VGND.n1059 VGND.n992 7.05766
R3449 VGND.n1120 VGND.n930 7.05766
R3450 VGND.n1129 VGND.n920 7.05766
R3451 VGND.n1154 VGND.n1033 6.69813
R3452 VGND.n1032 VGND.n1019 6.69813
R3453 VGND.n1053 VGND.n925 6.37009
R3454 VGND.n1086 VGND.n957 6.35195
R3455 VGND.t51 VGND.n934 6.35195
R3456 VGND.n1058 VGND.n993 6.35195
R3457 VGND.t53 VGND.n996 6.35195
R3458 VGND.n1049 VGND.n1002 6.35195
R3459 VGND.n1161 VGND.n905 6.35195
R3460 VGND.n1147 VGND.n903 5.99241
R3461 VGND.n1195 VGND.n19 0.545361
R3462 VGND.n49 VGND.n40 0.300442
R3463 VGND.n42 VGND.n894 0.0700707
R3464 VGND.n1093 VGND.n965 5.64623
R3465 VGND.n1162 VGND.n1074 5.64623
R3466 VGND.n1116 VGND.t51 5.64623
R3467 VGND.n1062 VGND.t8 5.64623
R3468 VGND.n1121 VGND.n929 5.64623
R3469 VGND.n1128 VGND.n921 5.64623
R3470 VGND.n24 VGND.n21 0.41921
R3471 VGND.n30 VGND.n28 0.545246
R3472 VGND.n18 VGND.n17 0.49612
R3473 VGND.n40 VGND.n898 5.43334
R3474 VGND.n1031 VGND.n1020 5.2867
R3475 VGND.n1087 VGND.n958 4.94051
R3476 VGND.t46 VGND.n956 4.94051
R3477 VGND.n1057 VGND.n994 4.94051
R3478 VGND.n1050 VGND.n1001 4.94051
R3479 VGND.n1205 VGND.n902 4.58098
R3480 VGND.t59 VGND.n1026 4.55958
R3481 VGND.n1226 VGND.n880 4.55917
R3482 VGND.n1026 VGND.n1025 4.50967
R3483 VGND.n1226 VGND.n1225 4.50967
R3484 VGND.n172 VGND.n838 4.5005
R3485 VGND.n1350 VGND.n1349 4.5005
R3486 VGND.n1348 VGND.n839 4.5005
R3487 VGND.n1347 VGND.n1346 4.5005
R3488 VGND.n1345 VGND.n840 4.5005
R3489 VGND.n1344 VGND.n1343 4.5005
R3490 VGND.n1342 VGND.n841 4.5005
R3491 VGND.n1341 VGND.n1340 4.5005
R3492 VGND.n1339 VGND.n842 4.5005
R3493 VGND.n1338 VGND.n1337 4.5005
R3494 VGND.n1336 VGND.n843 4.5005
R3495 VGND.n1335 VGND.n1334 4.5005
R3496 VGND.n1333 VGND.n844 4.5005
R3497 VGND.n1332 VGND.n1331 4.5005
R3498 VGND.n1330 VGND.n845 4.5005
R3499 VGND.n1329 VGND.n1328 4.5005
R3500 VGND.n1327 VGND.n846 4.5005
R3501 VGND.n1326 VGND.n1325 4.5005
R3502 VGND.n1324 VGND.n847 4.5005
R3503 VGND.n1323 VGND.n1322 4.5005
R3504 VGND.n1321 VGND.n848 4.5005
R3505 VGND.n1320 VGND.n1319 4.5005
R3506 VGND.n1318 VGND.n849 4.5005
R3507 VGND.n1317 VGND.n1316 4.5005
R3508 VGND.n1315 VGND.n850 4.5005
R3509 VGND.n1314 VGND.n1313 4.5005
R3510 VGND.n1312 VGND.n851 4.5005
R3511 VGND.n1311 VGND.n1310 4.5005
R3512 VGND.n1309 VGND.n852 4.5005
R3513 VGND.n1308 VGND.n1307 4.5005
R3514 VGND.n1306 VGND.n853 4.5005
R3515 VGND.n1305 VGND.n1304 4.5005
R3516 VGND.n1303 VGND.n854 4.5005
R3517 VGND.n1302 VGND.n1301 4.5005
R3518 VGND.n1300 VGND.n855 4.5005
R3519 VGND.n1299 VGND.n1298 4.5005
R3520 VGND.n1297 VGND.n856 4.5005
R3521 VGND.n1296 VGND.n1295 4.5005
R3522 VGND.n1294 VGND.n857 4.5005
R3523 VGND.n1293 VGND.n1292 4.5005
R3524 VGND.n1291 VGND.n858 4.5005
R3525 VGND.n1290 VGND.n1289 4.5005
R3526 VGND.n1288 VGND.n859 4.5005
R3527 VGND.n1287 VGND.n1286 4.5005
R3528 VGND.n1285 VGND.n860 4.5005
R3529 VGND.n1284 VGND.n1283 4.5005
R3530 VGND.n1282 VGND.n861 4.5005
R3531 VGND.n1281 VGND.n1280 4.5005
R3532 VGND.n1279 VGND.n862 4.5005
R3533 VGND.n1278 VGND.n1277 4.5005
R3534 VGND.n1276 VGND.n863 4.5005
R3535 VGND.n1275 VGND.n1274 4.5005
R3536 VGND.n1273 VGND.n864 4.5005
R3537 VGND.n1272 VGND.n1271 4.5005
R3538 VGND.n1270 VGND.n865 4.5005
R3539 VGND.n1269 VGND.n1268 4.5005
R3540 VGND.n1267 VGND.n866 4.5005
R3541 VGND.n1266 VGND.n1265 4.5005
R3542 VGND.n1264 VGND.n867 4.5005
R3543 VGND.n1263 VGND.n1262 4.5005
R3544 VGND.n1261 VGND.n868 4.5005
R3545 VGND.n1260 VGND.n1259 4.5005
R3546 VGND.n1258 VGND.n869 4.5005
R3547 VGND.n1257 VGND.n1256 4.5005
R3548 VGND.n1255 VGND.n870 4.5005
R3549 VGND.n1254 VGND.n1253 4.5005
R3550 VGND.n1252 VGND.n1251 4.5005
R3551 VGND.n1250 VGND.n872 4.5005
R3552 VGND.n1248 VGND.n1247 4.5005
R3553 VGND.n1246 VGND.n874 4.5005
R3554 VGND.n1245 VGND.n1244 4.5005
R3555 VGND.n1243 VGND.n875 4.5005
R3556 VGND.n1241 VGND.n1240 4.5005
R3557 VGND.n1239 VGND.n878 4.5005
R3558 VGND.n1238 VGND.n1237 4.5005
R3559 VGND.n1236 VGND.n879 4.5005
R3560 VGND.n1235 VGND.n1234 4.5005
R3561 VGND.n1233 VGND.n1228 4.5005
R3562 VGND.n1232 VGND.n1231 4.5005
R3563 VGND.n1230 VGND.n1229 4.5005
R3564 VGND.n1363 VGND.n1362 4.5005
R3565 VGND.n1361 VGND.n1360 4.5005
R3566 VGND.n1357 VGND.n832 4.5005
R3567 VGND.n1355 VGND.n1354 4.5005
R3568 VGND.n58 VGND.n1353 4.5005
R3569 VGND.n217 VGND.n58 2.23733
R3570 VGND.n1181 VGND.n1180 4.5005
R3571 VGND.n1191 VGND.n1190 4.5005
R3572 VGND.n1177 VGND.n1176 4.5005
R3573 VGND.n1187 VGND.n1186 4.5005
R3574 VGND.n1184 VGND.n1181 4.5005
R3575 VGND.n1192 VGND.n1191 4.5005
R3576 VGND.n1176 VGND.n1175 4.5005
R3577 VGND.n1186 VGND.n1185 4.5005
R3578 VGND.n1184 VGND.n1183 4.5005
R3579 VGND.n1175 VGND.n1174 4.5005
R3580 VGND.n1193 VGND.n1192 4.5005
R3581 VGND.n1185 VGND.n1168 4.5005
R3582 VGND.t19 VGND.n399 4.49686
R3583 VGND.t19 VGND.n220 1.12175
R3584 VGND.t21 VGND.n408 4.49686
R3585 VGND.t21 VGND.n411 4.49686
R3586 VGND.t21 VGND.n405 4.49686
R3587 VGND.t21 VGND.n412 4.49686
R3588 VGND.t23 VGND.n421 4.49686
R3589 VGND.t23 VGND.n56 1.12175
R3590 VGND.n1179 VGND.n1177 4.49509
R3591 VGND.n1189 VGND.n1188 4.48628
R3592 VGND.n43 VGND.n37 4.40722
R3593 VGND.n1223 VGND.n1209 4.24636
R3594 VGND.n40 VGND.n883 4.24249
R3595 VGND.n1158 VGND.n25 0.509501
R3596 VGND.n1092 VGND.n964 4.2348
R3597 VGND.n1122 VGND.n928 4.2348
R3598 VGND.n1127 VGND.n922 4.2348
R3599 VGND.n1030 VGND.n1021 3.87526
R3600 VGND.n1029 VGND.n1022 3.83555
R3601 VGND.n1088 VGND.n959 3.52908
R3602 VGND.n1056 VGND.n995 3.52908
R3603 VGND.n1051 VGND.n1000 3.52908
R3604 VGND.n1153 VGND.n904 3.52908
R3605 VGND.n1206 VGND.n901 3.16955
R3606 VGND.t3 VGND.n11 3.16936
R3607 VGND.n1896 VGND.n1893 3.01808
R3608 VGND.n1911 VGND.n1910 3.0093
R3609 VGND.n548 VGND.n547 3.00929
R3610 VGND.n526 VGND.n485 3.00929
R3611 VGND.n577 VGND.n576 3.00929
R3612 VGND.n550 VGND.n471 3.00929
R3613 VGND.n601 VGND.n600 3.00929
R3614 VGND.n579 VGND.n453 3.00929
R3615 VGND.n527 VGND.n526 3.0005
R3616 VGND.n528 VGND.n487 3.0005
R3617 VGND.n530 VGND.n529 3.0005
R3618 VGND.n483 VGND.n482 3.0005
R3619 VGND.n535 VGND.n534 3.0005
R3620 VGND.n536 VGND.n481 3.0005
R3621 VGND.n480 VGND.n479 3.0005
R3622 VGND.n541 VGND.n540 3.0005
R3623 VGND.n542 VGND.n478 3.0005
R3624 VGND.n544 VGND.n543 3.0005
R3625 VGND.n475 VGND.n474 3.0005
R3626 VGND.n551 VGND.n550 3.0005
R3627 VGND.n552 VGND.n473 3.0005
R3628 VGND.n554 VGND.n553 3.0005
R3629 VGND.n469 VGND.n468 3.0005
R3630 VGND.n561 VGND.n560 3.0005
R3631 VGND.n562 VGND.n467 3.0005
R3632 VGND.n463 VGND.n462 3.0005
R3633 VGND.n570 VGND.n569 3.0005
R3634 VGND.n571 VGND.n461 3.0005
R3635 VGND.n573 VGND.n572 3.0005
R3636 VGND.n457 VGND.n456 3.0005
R3637 VGND.n580 VGND.n579 3.0005
R3638 VGND.n581 VGND.n455 3.0005
R3639 VGND.n583 VGND.n582 3.0005
R3640 VGND.n451 VGND.n450 3.0005
R3641 VGND.n588 VGND.n587 3.0005
R3642 VGND.n589 VGND.n449 3.0005
R3643 VGND.n448 VGND.n447 3.0005
R3644 VGND.n594 VGND.n593 3.0005
R3645 VGND.n595 VGND.n446 3.0005
R3646 VGND.n597 VGND.n596 3.0005
R3647 VGND.n443 VGND.n442 3.0005
R3648 VGND.n1912 VGND.n1911 3.0005
R3649 VGND.n1913 VGND.n441 3.0005
R3650 VGND.n1915 VGND.n1914 3.0005
R3651 VGND.n1916 VGND.n437 3.0005
R3652 VGND.n1918 VGND.n1917 3.0005
R3653 VGND.n1919 VGND.n435 3.0005
R3654 VGND.n436 VGND.n434 3.0005
R3655 VGND.n1903 VGND.n1902 3.0005
R3656 VGND.n1901 VGND.n1892 3.0005
R3657 VGND.n1900 VGND.n1899 3.0005
R3658 VGND.n549 VGND.n548 3.0005
R3659 VGND.n578 VGND.n577 3.0005
R3660 VGND.n602 VGND.n601 3.0005
R3661 VGND.n603 VGND.n441 3.0005
R3662 VGND.n1915 VGND.n440 3.0005
R3663 VGND.n1916 VGND.n439 3.0005
R3664 VGND.n1917 VGND.n438 3.0005
R3665 VGND.n435 VGND.n433 3.0005
R3666 VGND.n434 VGND.n432 3.0005
R3667 VGND.n1904 VGND.n1903 3.0005
R3668 VGND.n1892 VGND.n1891 3.0005
R3669 VGND.n1899 VGND.n1898 3.0005
R3670 VGND.n1895 VGND.n1894 3.0005
R3671 VGND.n1909 VGND.n440 3.0005
R3672 VGND.n1908 VGND.n439 3.0005
R3673 VGND.n1907 VGND.n438 3.0005
R3674 VGND.n1906 VGND.n433 3.0005
R3675 VGND.n1905 VGND.n432 3.0005
R3676 VGND.n430 VGND.n1904 3.0005
R3677 VGND.n1891 VGND.n1890 3.0005
R3678 VGND.n1898 VGND.n1897 3.0005
R3679 VGND.n2010 VGND.n2009 3.0005
R3680 VGND.n2008 VGND.n2007 3.0005
R3681 VGND.n57 VGND.t19 1.79831
R3682 VGND.n220 VGND.n2017 0.010059
R3683 VGND.n2005 VGND.n238 0.0104363
R3684 VGND.n238 VGND.t19 1.12175
R3685 VGND.t19 VGND.n161 1.79831
R3686 VGND.n66 VGND.t19 2.2479
R3687 VGND.n532 VGND.n531 3.0005
R3688 VGND.n60 VGND.n484 3.0005
R3689 VGND.n533 VGND.n61 0.00925955
R3690 VGND.t34 VGND.n61 1.49687
R3691 VGND.n59 VGND.n252 0.0151318
R3692 VGND.n539 VGND.n218 0.00925955
R3693 VGND.n218 VGND.t34 1.49687
R3694 VGND.n546 VGND.n545 3.0005
R3695 VGND.n487 VGND.n486 3.0005
R3696 VGND.n531 VGND.n530 3.0005
R3697 VGND.n484 VGND.n483 3.0005
R3698 VGND.n534 VGND.n533 3.0005
R3699 VGND.n481 VGND.n157 3.0005
R3700 VGND.n252 VGND.n480 3.0005
R3701 VGND.n540 VGND.n539 3.0005
R3702 VGND.n478 VGND.n477 3.0005
R3703 VGND.n545 VGND.n544 3.0005
R3704 VGND.n476 VGND.n475 3.0005
R3705 VGND.n1970 VGND.n1969 3.0005
R3706 VGND.n1967 VGND.n406 3.0005
R3707 VGND.n1977 VGND.n1976 3.0005
R3708 VGND.n1979 VGND.n1978 3.0005
R3709 VGND.n1965 VGND.n1961 3.0005
R3710 VGND.n1987 VGND.n1986 3.0005
R3711 VGND.n1988 VGND.n404 3.0005
R3712 VGND.n1990 VGND.n1989 3.0005
R3713 VGND.n556 VGND.n555 3.0005
R3714 VGND.n557 VGND.n470 3.0005
R3715 VGND.n559 VGND.n558 3.0005
R3716 VGND.n466 VGND.n465 3.0005
R3717 VGND.n566 VGND.n464 3.0005
R3718 VGND.n568 VGND.n567 3.0005
R3719 VGND.n460 VGND.n459 3.0005
R3720 VGND.n575 VGND.n574 3.0005
R3721 VGND.n473 VGND.n472 3.0005
R3722 VGND.n555 VGND.n554 3.0005
R3723 VGND.n470 VGND.n469 3.0005
R3724 VGND.n560 VGND.n559 3.0005
R3725 VGND.n467 VGND.n466 3.0005
R3726 VGND.n464 VGND.n463 3.0005
R3727 VGND.n569 VGND.n568 3.0005
R3728 VGND.n461 VGND.n460 3.0005
R3729 VGND.n574 VGND.n573 3.0005
R3730 VGND.n458 VGND.n457 3.0005
R3731 VGND.n1934 VGND.n1933 3.0005
R3732 VGND.n56 VGND.n1940 0.010059
R3733 VGND.n255 VGND.t23 1.12175
R3734 VGND.n1928 VGND.n255 0.010059
R3735 VGND.t23 VGND.n221 1.12175
R3736 VGND.n1949 VGND.n221 0.010059
R3737 VGND.n160 VGND.t23 1.79831
R3738 VGND.n585 VGND.n584 3.0005
R3739 VGND.n63 VGND.n452 3.0005
R3740 VGND.n586 VGND.n64 0.00925955
R3741 VGND.t38 VGND.n64 1.49687
R3742 VGND.n62 VGND.n253 0.0151318
R3743 VGND.n592 VGND.n219 0.00925955
R3744 VGND.n219 VGND.t38 1.49687
R3745 VGND.n599 VGND.n598 3.0005
R3746 VGND.n455 VGND.n454 3.0005
R3747 VGND.n584 VGND.n583 3.0005
R3748 VGND.n452 VGND.n451 3.0005
R3749 VGND.n587 VGND.n586 3.0005
R3750 VGND.n449 VGND.n156 3.0005
R3751 VGND.n253 VGND.n448 3.0005
R3752 VGND.n593 VGND.n592 3.0005
R3753 VGND.n446 VGND.n445 3.0005
R3754 VGND.n598 VGND.n597 3.0005
R3755 VGND.n444 VGND.n443 3.0005
R3756 VGND.n1351 VGND.n51 2.87922
R3757 VGND.n1358 VGND.n834 2.86394
R3758 VGND.n1430 VGND.n129 2.83988
R3759 VGND.n1242 VGND.n877 2.83257
R3760 VGND.n889 VGND.n876 2.83157
R3761 VGND.n1249 VGND.n873 2.83157
R3762 VGND.n1085 VGND.t46 2.82337
R3763 VGND.n1070 VGND.t50 2.82337
R3764 VGND.n1123 VGND.n927 2.82337
R3765 VGND.n1126 VGND.n923 2.82337
R3766 VGND.n129 VGND.n1472 2.81238
R3767 VGND.n129 VGND.n815 2.81238
R3768 VGND.n129 VGND.n807 2.81238
R3769 VGND.n129 VGND.n805 2.81238
R3770 VGND.n129 VGND.n1413 2.81238
R3771 VGND.n129 VGND.n798 2.81238
R3772 VGND.n129 VGND.n796 2.81238
R3773 VGND.n129 VGND.n788 2.81238
R3774 VGND.n1423 VGND.n129 2.81238
R3775 VGND.n1428 VGND.n129 2.81238
R3776 VGND.n1195 VGND.n22 0.159602
R3777 VGND.n67 VGND.n50 2.79168
R3778 VGND.n1470 VGND.n129 2.78217
R3779 VGND.n1352 VGND.n837 2.77717
R3780 VGND.n1159 VGND.n836 2.77717
R3781 VGND.n1356 VGND.n835 2.77717
R3782 VGND.n1359 VGND.n833 2.77717
R3783 VGND.n1155 VGND.n831 2.77717
R3784 VGND.n1207 VGND.n900 2.73503
R3785 VGND.n129 VGND.n817 2.72717
R3786 VGND.n129 VGND.n10 2.72717
R3787 VGND.n1091 VGND.n963 2.46383
R3788 VGND.n1161 VGND.n1145 2.46383
R3789 VGND.n615 VGND.n614 2.26806
R3790 VGND.n1923 VGND.n1922 2.2505
R3791 VGND.n426 VGND.n425 2.2505
R3792 VGND.n628 VGND.n627 2.2505
R3793 VGND.n629 VGND.n624 2.2505
R3794 VGND.n631 VGND.n630 2.2505
R3795 VGND.n606 VGND.n604 2.2505
R3796 VGND.n428 VGND.n637 2.2505
R3797 VGND.n605 VGND.n427 2.2505
R3798 VGND.n618 VGND.n617 2.2505
R3799 VGND.n616 VGND.n611 2.2505
R3800 VGND.n1924 VGND.n1923 2.2505
R3801 VGND.n425 VGND.n424 2.2505
R3802 VGND.n627 VGND.n626 2.2505
R3803 VGND.n624 VGND.n623 2.2505
R3804 VGND.n632 VGND.n631 2.2505
R3805 VGND.n608 VGND.n606 2.2505
R3806 VGND.n637 VGND.n636 2.2505
R3807 VGND.n607 VGND.n605 2.2505
R3808 VGND.n619 VGND.n618 2.2505
R3809 VGND.n611 VGND.n610 2.2505
R3810 VGND.n613 VGND.n612 2.2505
R3811 VGND.n610 VGND.n609 2.2505
R3812 VGND.n620 VGND.n619 2.2505
R3813 VGND.n621 VGND.n607 2.2505
R3814 VGND.n636 VGND.n635 2.2505
R3815 VGND.n634 VGND.n608 2.2505
R3816 VGND.n633 VGND.n632 2.2505
R3817 VGND.n623 VGND.n622 2.2505
R3818 VGND.n626 VGND.n625 2.2505
R3819 VGND.n424 VGND.n423 2.2505
R3820 VGND.n1925 VGND.n1924 2.2505
R3821 VGND.n1955 VGND.n1954 2.2505
R3822 VGND.n1953 VGND.n422 2.2505
R3823 VGND.n1952 VGND.n1951 2.2505
R3824 VGND.n1927 VGND.n1926 2.2505
R3825 VGND.n1947 VGND.n1946 2.2505
R3826 VGND.n1945 VGND.n1929 2.2505
R3827 VGND.n1944 VGND.n1943 2.2505
R3828 VGND.n1931 VGND.n1930 2.2505
R3829 VGND.n1939 VGND.n1938 2.2505
R3830 VGND.n1937 VGND.n1932 2.2505
R3831 VGND.n1936 VGND.n1935 2.2505
R3832 VGND.n417 VGND.n416 2.2505
R3833 VGND.n1995 VGND.n1994 2.2505
R3834 VGND.n1993 VGND.n415 2.2505
R3835 VGND.n1992 VGND.n1991 2.2505
R3836 VGND.n1960 VGND.n1959 2.2505
R3837 VGND.n1985 VGND.n1984 2.2505
R3838 VGND.n1983 VGND.n1962 2.2505
R3839 VGND.n1982 VGND.n1981 2.2505
R3840 VGND.n1964 VGND.n1963 2.2505
R3841 VGND.n1975 VGND.n1974 2.2505
R3842 VGND.n1973 VGND.n1968 2.2505
R3843 VGND.n1972 VGND.n1971 2.2505
R3844 VGND.n402 VGND.n401 2.2505
R3845 VGND.n2031 VGND.n2030 2.2505
R3846 VGND.n2029 VGND.n400 2.2505
R3847 VGND.n2028 VGND.n2027 2.2505
R3848 VGND.n2001 VGND.n2000 2.2505
R3849 VGND.n2023 VGND.n2022 2.2505
R3850 VGND.n2021 VGND.n2002 2.2505
R3851 VGND.n2020 VGND.n2019 2.2505
R3852 VGND.n2004 VGND.n2003 2.2505
R3853 VGND.n2015 VGND.n2014 2.2505
R3854 VGND.n2013 VGND.n2006 2.2505
R3855 VGND.n2012 VGND.n2011 2.2505
R3856 VGND.n395 VGND.n394 2.2505
R3857 VGND.n1958 VGND.n1957 2.2505
R3858 VGND.n1999 VGND.n1998 2.2505
R3859 VGND.n2034 VGND.n2033 2.2505
R3860 VGND.n2033 VGND.n2032 2.2505
R3861 VGND.n398 VGND.n395 2.2505
R3862 VGND.n2011 VGND.n2010 2.2505
R3863 VGND.n2007 VGND.n2006 2.2505
R3864 VGND.n2016 VGND.n2015 2.2505
R3865 VGND.n2017 VGND.n2004 2.2505
R3866 VGND.n2019 VGND.n2018 2.2505
R3867 VGND.n2005 VGND.n2002 2.2505
R3868 VGND.n2024 VGND.n2023 2.2505
R3869 VGND.n2025 VGND.n2001 2.2505
R3870 VGND.n2027 VGND.n2026 2.2505
R3871 VGND.n400 VGND.n397 2.2505
R3872 VGND.n1998 VGND.n1997 2.2505
R3873 VGND.n407 VGND.n402 2.2505
R3874 VGND.n1971 VGND.n1970 2.2505
R3875 VGND.n1968 VGND.n406 2.2505
R3876 VGND.n1976 VGND.n1975 2.2505
R3877 VGND.n1979 VGND.n1964 2.2505
R3878 VGND.n1981 VGND.n1980 2.2505
R3879 VGND.n1965 VGND.n1962 2.2505
R3880 VGND.n1986 VGND.n1985 2.2505
R3881 VGND.n1960 VGND.n404 2.2505
R3882 VGND.n1991 VGND.n1990 2.2505
R3883 VGND.n415 VGND.n414 2.2505
R3884 VGND.n1996 VGND.n1995 2.2505
R3885 VGND.n1957 VGND.n1956 2.2505
R3886 VGND.n420 VGND.n417 2.2505
R3887 VGND.n1935 VGND.n1934 2.2505
R3888 VGND.n1932 VGND.n419 2.2505
R3889 VGND.n1940 VGND.n1939 2.2505
R3890 VGND.n1941 VGND.n1931 2.2505
R3891 VGND.n1943 VGND.n1942 2.2505
R3892 VGND.n1929 VGND.n1928 2.2505
R3893 VGND.n1948 VGND.n1947 2.2505
R3894 VGND.n1949 VGND.n1927 2.2505
R3895 VGND.n1951 VGND.n1950 2.2505
R3896 VGND.n422 VGND.n158 2.2505
R3897 VGND.n1980 VGND.n409 2.25022
R3898 VGND.n224 VGND.n129 1.04486
R3899 VGND.n1055 VGND.n996 2.11765
R3900 VGND.n1052 VGND.n999 2.11765
R3901 VGND.n1224 VGND.n41 1.54638
R3902 VGND.n1223 VGND.n1222 1.88939
R3903 VGND.n1028 VGND.n1023 1.63452
R3904 VGND.n39 VGND.n43 1.5464
R3905 VGND.n1432 VGND.n1431 1.53048
R3906 VGND.n1910 VGND.n1909 1.52923
R3907 VGND.n1897 VGND.n1896 1.52923
R3908 VGND.n2009 VGND.n396 1.52365
R3909 VGND.n1969 VGND.n403 1.52365
R3910 VGND.n1989 VGND.n413 1.52365
R3911 VGND.n1933 VGND.n418 1.52365
R3912 VGND.t23 VGND.n159 1.3026
R3913 VGND.n532 VGND.n485 1.52352
R3914 VGND.n547 VGND.n546 1.52352
R3915 VGND.n556 VGND.n471 1.52352
R3916 VGND.n576 VGND.n575 1.52352
R3917 VGND.n585 VGND.n453 1.52352
R3918 VGND.n600 VGND.n599 1.52352
R3919 VGND.n1900 VGND.n1893 1.51756
R3920 VGND.n2067 VGND.n2066 1.50925
R3921 VGND.n524 VGND.n523 1.50925
R3922 VGND.n494 VGND.n162 1.5005
R3923 VGND.n521 VGND.n520 1.5005
R3924 VGND.n519 VGND.n493 1.5005
R3925 VGND.n518 VGND.n517 1.5005
R3926 VGND.n515 VGND.n495 1.5005
R3927 VGND.n512 VGND.n511 1.5005
R3928 VGND.n510 VGND.n496 1.5005
R3929 VGND.n509 VGND.n508 1.5005
R3930 VGND.n505 VGND.n497 1.5005
R3931 VGND.n502 VGND.n501 1.5005
R3932 VGND.n500 VGND.n499 1.5005
R3933 VGND.n489 VGND.n488 1.5005
R3934 VGND.n525 VGND.n524 1.5005
R3935 VGND.n163 VGND.n2067 1.5005
R3936 VGND.n380 VGND.n379 1.5005
R3937 VGND.n2049 VGND.n2048 1.5005
R3938 VGND.n2050 VGND.n2046 1.5005
R3939 VGND.n2052 VGND.n2051 1.5005
R3940 VGND.n2053 VGND.n2041 1.5005
R3941 VGND.n2055 VGND.n2054 1.5005
R3942 VGND.n2056 VGND.n2040 1.5005
R3943 VGND.n2058 VGND.n2057 1.5005
R3944 VGND.n2059 VGND.n2035 1.5005
R3945 VGND.n2061 VGND.n2060 1.5005
R3946 VGND.n2062 VGND.n393 1.5005
R3947 VGND.n2064 VGND.n2063 1.5005
R3948 VGND.n381 VGND.n380 1.5005
R3949 VGND.n2048 VGND.n2047 1.5005
R3950 VGND.n2046 VGND.n2045 1.5005
R3951 VGND.n2052 VGND.n2044 1.5005
R3952 VGND.n2053 VGND.n2043 1.5005
R3953 VGND.n2054 VGND.n2042 1.5005
R3954 VGND.n2040 VGND.n2039 1.5005
R3955 VGND.n2058 VGND.n2038 1.5005
R3956 VGND.n2059 VGND.n2037 1.5005
R3957 VGND.n2060 VGND.n2036 1.5005
R3958 VGND.n393 VGND.n392 1.5005
R3959 VGND.n2065 VGND.n2064 1.5005
R3960 VGND.t17 VGND.n2065 1.5005
R3961 VGND.t32 VGND.n491 1.5005
R3962 VGND.n494 VGND.n491 1.5005
R3963 VGND.n522 VGND.n521 1.5005
R3964 VGND.n493 VGND.n492 1.5005
R3965 VGND.n517 VGND.n516 1.5005
R3966 VGND.n515 VGND.n514 1.5005
R3967 VGND.n513 VGND.n512 1.5005
R3968 VGND.n506 VGND.n496 1.5005
R3969 VGND.n508 VGND.n507 1.5005
R3970 VGND.n505 VGND.n504 1.5005
R3971 VGND.n503 VGND.n502 1.5005
R3972 VGND.n499 VGND.n498 1.5005
R3973 VGND.n490 VGND.n489 1.5005
R3974 VGND.t11 VGND.n36 29.1822
R3975 VGND.n1124 VGND.n926 1.41193
R3976 VGND.n1125 VGND.n924 1.41193
R3977 VGND.n1154 VGND.n1018 1.41193
R3978 VGND.n1089 VGND.n960 1.3843
R3979 VGND.n1431 VGND.n1430 1.34405
R3980 VGND.t2 VGND.n35 25.5548
R3981 VGND.t49 VGND.t52 1.27314
R3982 VGND.n0 VGND.t4 1.25956
R3983 VGND.n36 VGND.t13 15.2446
R3984 VGND.n33 VGND.n1200 3.91094
R3985 VGND.t0 VGND.t58 1.19524
R3986 VGND.n614 VGND.n609 1.14256
R3987 VGND.n616 VGND.n615 1.13618
R3988 VGND.n49 VGND.n1196 5824.24
R3989 VGND.n1223 VGND.n1053 1.06645
R3990 VGND.n40 VGND.n37 0.946337
R3991 VGND.t4 VGND.n1167 0.882463
R3992 VGND.t16 VGND.n26 0.391651
R3993 VGND.n38 VGND.t59 0.825448
R3994 VGND.n2066 VGND.t17 0.746874
R3995 VGND.t17 VGND.n382 0.746874
R3996 VGND.t17 VGND.n383 0.746874
R3997 VGND.t17 VGND.n384 0.746874
R3998 VGND.t17 VGND.n385 0.746874
R3999 VGND.t17 VGND.n386 0.746874
R4000 VGND.t32 VGND.n391 0.746874
R4001 VGND.t32 VGND.n390 0.746874
R4002 VGND.t32 VGND.n389 0.746874
R4003 VGND.t32 VGND.n388 0.746874
R4004 VGND.t32 VGND.n387 0.746874
R4005 VGND.n523 VGND.t32 0.746874
R4006 VGND.t49 VGND.n880 0.718859
R4007 VGND.n1224 VGND.n897 0.706216
R4008 VGND.n961 VGND.n897 0.706216
R4009 VGND.n1054 VGND.n997 0.706216
R4010 VGND.n1027 VGND.n898 0.704986
R4011 VGND.n13 VGND.n12 0.649312
R4012 VGND.n1921 VGND.n1920 0.692808
R4013 VGND.n431 VGND.n1921 0.692808
R4014 VGND.n429 VGND.n431 0.692808
R4015 VGND.n1138 VGND.n1217 0.682773
R4016 VGND.n27 VGND.n25 0.255636
R4017 VGND.n1214 VGND.n38 0.659933
R4018 VGND.n26 VGND.n32 0.679755
R4019 VGND.n1167 VGND.n1 0.691595
R4020 VGND.n46 VGND.n1198 0.620059
R4021 VGND.n1167 VGND.n47 0.636148
R4022 VGND.t34 VGND.n59 0.427486
R4023 VGND.t38 VGND.n62 0.427486
R4024 VGND.n1026 VGND.n871 0.570962
R4025 VGND.n1227 VGND.n1226 0.567
R4026 VGND.n1208 VGND.n899 0.534004
R4027 VGND.n538 VGND.n537 0.5005
R4028 VGND.n564 VGND.n563 0.5005
R4029 VGND.n591 VGND.n590 0.5005
R4030 VGND.n261 VGND.n538 0.5005
R4031 VGND.n410 VGND.n564 0.5005
R4032 VGND.n260 VGND.n591 0.5005
R4033 VGND.t36 VGND.n410 0.500439
R4034 VGND.n44 VGND.n13 0.398614
R4035 VGND.n1222 VGND.n898 0.352977
R4036 VGND.t16 VGND.n25 0.779692
R4037 VGND.t17 VGND.t32 0.3151
R4038 VGND.n18 VGND.n34 1.52777
R4039 VGND.t21 VGND.t36 0.288035
R4040 VGND.t23 VGND.t38 0.286862
R4041 VGND.t19 VGND.t34 0.286862
R4042 VGND VGND.n2071 0.255776
R4043 VGND.n1470 VGND.n18 1.11699
R4044 VGND.n1189 VGND.t9 0.209531
R4045 VGND.n1368 VGND.n1365 0.189571
R4046 VGND.n1552 VGND.n1551 0.188
R4047 VGND.n718 VGND.n717 0.188
R4048 VGND.n1546 VGND.n1545 0.188
R4049 VGND.n1544 VGND.n721 0.188
R4050 VGND.n1543 VGND.n1542 0.188
R4051 VGND.n723 VGND.n722 0.188
R4052 VGND.n1534 VGND.n727 0.188
R4053 VGND.n1536 VGND.n1535 0.188
R4054 VGND.n1533 VGND.n726 0.188
R4055 VGND.n1532 VGND.n1531 0.188
R4056 VGND.n729 VGND.n728 0.188
R4057 VGND.n1523 VGND.n733 0.188
R4058 VGND.n1525 VGND.n1524 0.188
R4059 VGND.n1522 VGND.n732 0.188
R4060 VGND.n1521 VGND.n1520 0.188
R4061 VGND.n735 VGND.n734 0.188
R4062 VGND.n1512 VGND.n739 0.188
R4063 VGND.n1514 VGND.n1513 0.188
R4064 VGND.n1511 VGND.n738 0.188
R4065 VGND.n1510 VGND.n1509 0.188
R4066 VGND.n741 VGND.n740 0.188
R4067 VGND.n1501 VGND.n745 0.188
R4068 VGND.n1503 VGND.n1502 0.188
R4069 VGND.n1500 VGND.n744 0.188
R4070 VGND.n1499 VGND.n1498 0.188
R4071 VGND.n747 VGND.n746 0.188
R4072 VGND.n1490 VGND.n751 0.188
R4073 VGND.n1492 VGND.n1491 0.188
R4074 VGND.n1489 VGND.n750 0.188
R4075 VGND.n1488 VGND.n1487 0.188
R4076 VGND.n753 VGND.n752 0.188
R4077 VGND.n1479 VGND.n757 0.188
R4078 VGND.n1481 VGND.n1480 0.188
R4079 VGND.n1478 VGND.n756 0.188
R4080 VGND.n1477 VGND.n1476 0.188
R4081 VGND.n759 VGND.n758 0.188
R4082 VGND.n1419 VGND.n791 0.188
R4083 VGND.n1421 VGND.n1420 0.188
R4084 VGND.n1418 VGND.n790 0.188
R4085 VGND.n1417 VGND.n1416 0.188
R4086 VGND.n793 VGND.n792 0.188
R4087 VGND.n1409 VGND.n1408 0.188
R4088 VGND.n1407 VGND.n800 0.188
R4089 VGND.n1406 VGND.n1405 0.188
R4090 VGND.n802 VGND.n801 0.188
R4091 VGND.n1398 VGND.n810 0.188
R4092 VGND.n1400 VGND.n1399 0.188
R4093 VGND.n1397 VGND.n809 0.188
R4094 VGND.n1396 VGND.n1395 0.188
R4095 VGND.n812 VGND.n811 0.188
R4096 VGND.n1390 VGND.n1389 0.188
R4097 VGND.n1388 VGND.n819 0.188
R4098 VGND.n1387 VGND.n1386 0.188
R4099 VGND.n821 VGND.n820 0.188
R4100 VGND.n1379 VGND.n825 0.188
R4101 VGND.n1381 VGND.n1380 0.188
R4102 VGND.n1378 VGND.n824 0.188
R4103 VGND.n1377 VGND.n1376 0.188
R4104 VGND.n827 VGND.n826 0.188
R4105 VGND.n1371 VGND.n1370 0.188
R4106 VGND.n1369 VGND.n830 0.188
R4107 VGND.n1555 VGND.n1554 0.188
R4108 VGND.n1885 VGND.n1884 0.188
R4109 VGND.n1680 VGND.n646 0.188
R4110 VGND.n1679 VGND.n1678 0.188
R4111 VGND.n1677 VGND.n647 0.188
R4112 VGND.n1676 VGND.n1675 0.188
R4113 VGND.n1674 VGND.n648 0.188
R4114 VGND.n1673 VGND.n1672 0.188
R4115 VGND.n1671 VGND.n650 0.188
R4116 VGND.n1669 VGND.n1668 0.188
R4117 VGND.n1667 VGND.n651 0.188
R4118 VGND.n1666 VGND.n1665 0.188
R4119 VGND.n653 VGND.n652 0.188
R4120 VGND.n1655 VGND.n657 0.188
R4121 VGND.n1657 VGND.n1656 0.188
R4122 VGND.n1654 VGND.n656 0.188
R4123 VGND.n1653 VGND.n1652 0.188
R4124 VGND.n1651 VGND.n658 0.188
R4125 VGND.n1644 VGND.n659 0.188
R4126 VGND.n1646 VGND.n1645 0.188
R4127 VGND.n1643 VGND.n662 0.188
R4128 VGND.n1642 VGND.n1641 0.188
R4129 VGND.n664 VGND.n663 0.188
R4130 VGND.n1637 VGND.n1636 0.188
R4131 VGND.n1635 VGND.n667 0.188
R4132 VGND.n1634 VGND.n1633 0.188
R4133 VGND.n669 VGND.n668 0.188
R4134 VGND.n1629 VGND.n1628 0.188
R4135 VGND.n1627 VGND.n672 0.188
R4136 VGND.n1626 VGND.n1625 0.188
R4137 VGND.n674 VGND.n673 0.188
R4138 VGND.n1621 VGND.n1620 0.188
R4139 VGND.n1619 VGND.n677 0.188
R4140 VGND.n1618 VGND.n1617 0.188
R4141 VGND.n679 VGND.n678 0.188
R4142 VGND.n1613 VGND.n1612 0.188
R4143 VGND.n1611 VGND.n682 0.188
R4144 VGND.n1610 VGND.n1609 0.188
R4145 VGND.n684 VGND.n683 0.188
R4146 VGND.n1605 VGND.n1604 0.188
R4147 VGND.n1603 VGND.n688 0.188
R4148 VGND.n1602 VGND.n1601 0.188
R4149 VGND.n690 VGND.n689 0.188
R4150 VGND.n1597 VGND.n1596 0.188
R4151 VGND.n1595 VGND.n694 0.188
R4152 VGND.n1594 VGND.n1593 0.188
R4153 VGND.n696 VGND.n695 0.188
R4154 VGND.n1588 VGND.n1587 0.188
R4155 VGND.n1586 VGND.n699 0.188
R4156 VGND.n1585 VGND.n1584 0.188
R4157 VGND.n701 VGND.n700 0.188
R4158 VGND.n1577 VGND.n705 0.188
R4159 VGND.n1579 VGND.n1578 0.188
R4160 VGND.n1576 VGND.n704 0.188
R4161 VGND.n1575 VGND.n1574 0.188
R4162 VGND.n707 VGND.n706 0.188
R4163 VGND.n1569 VGND.n1568 0.188
R4164 VGND.n1567 VGND.n710 0.188
R4165 VGND.n1566 VGND.n1565 0.188
R4166 VGND.n712 VGND.n711 0.188
R4167 VGND.n1557 VGND.n716 0.188
R4168 VGND.n1559 VGND.n1558 0.188
R4169 VGND.n1556 VGND.n715 0.188
R4170 VGND.n1883 VGND.n1882 0.188
R4171 VGND.n2071 VGND.n2070 0.188
R4172 VGND.n377 VGND.n376 0.188
R4173 VGND.n1793 VGND.n1792 0.188
R4174 VGND.n1794 VGND.n1755 0.188
R4175 VGND.n1796 VGND.n1795 0.188
R4176 VGND.n1797 VGND.n1751 0.188
R4177 VGND.n1799 VGND.n1798 0.188
R4178 VGND.n1800 VGND.n1750 0.188
R4179 VGND.n1802 VGND.n1801 0.188
R4180 VGND.n1803 VGND.n1746 0.188
R4181 VGND.n1805 VGND.n1804 0.188
R4182 VGND.n1806 VGND.n1745 0.188
R4183 VGND.n1808 VGND.n1807 0.188
R4184 VGND.n1809 VGND.n1741 0.188
R4185 VGND.n1811 VGND.n1810 0.188
R4186 VGND.n1812 VGND.n1740 0.188
R4187 VGND.n1814 VGND.n1813 0.188
R4188 VGND.n1815 VGND.n1736 0.188
R4189 VGND.n1817 VGND.n1816 0.188
R4190 VGND.n1818 VGND.n1735 0.188
R4191 VGND.n1820 VGND.n1819 0.188
R4192 VGND.n1821 VGND.n1731 0.188
R4193 VGND.n1823 VGND.n1822 0.188
R4194 VGND.n1824 VGND.n1730 0.188
R4195 VGND.n1826 VGND.n1825 0.188
R4196 VGND.n1827 VGND.n1726 0.188
R4197 VGND.n1829 VGND.n1828 0.188
R4198 VGND.n1830 VGND.n1725 0.188
R4199 VGND.n1832 VGND.n1831 0.188
R4200 VGND.n1833 VGND.n1721 0.188
R4201 VGND.n1835 VGND.n1834 0.188
R4202 VGND.n1836 VGND.n1720 0.188
R4203 VGND.n1838 VGND.n1837 0.188
R4204 VGND.n1839 VGND.n1716 0.188
R4205 VGND.n1841 VGND.n1840 0.188
R4206 VGND.n1842 VGND.n1715 0.188
R4207 VGND.n1844 VGND.n1843 0.188
R4208 VGND.n1845 VGND.n1711 0.188
R4209 VGND.n1847 VGND.n1846 0.188
R4210 VGND.n1848 VGND.n1710 0.188
R4211 VGND.n1850 VGND.n1849 0.188
R4212 VGND.n1851 VGND.n1706 0.188
R4213 VGND.n1853 VGND.n1852 0.188
R4214 VGND.n1854 VGND.n1705 0.188
R4215 VGND.n1856 VGND.n1855 0.188
R4216 VGND.n1857 VGND.n1701 0.188
R4217 VGND.n1859 VGND.n1858 0.188
R4218 VGND.n1860 VGND.n1700 0.188
R4219 VGND.n1862 VGND.n1861 0.188
R4220 VGND.n1863 VGND.n1696 0.188
R4221 VGND.n1865 VGND.n1864 0.188
R4222 VGND.n1866 VGND.n1695 0.188
R4223 VGND.n1868 VGND.n1867 0.188
R4224 VGND.n1869 VGND.n1691 0.188
R4225 VGND.n1871 VGND.n1870 0.188
R4226 VGND.n1872 VGND.n1690 0.188
R4227 VGND.n1874 VGND.n1873 0.188
R4228 VGND.n1875 VGND.n1686 0.188
R4229 VGND.n1877 VGND.n1876 0.188
R4230 VGND.n1878 VGND.n1685 0.188
R4231 VGND.n1880 VGND.n1879 0.188
R4232 VGND.n1881 VGND.n1681 0.188
R4233 VGND.n1882 VGND.n1682 0.188
R4234 VGND.n2070 VGND.n2069 0.188
R4235 VGND.n378 VGND.n377 0.188
R4236 VGND.n1792 VGND.n1791 0.188
R4237 VGND.n1756 VGND.n1755 0.188
R4238 VGND.n1796 VGND.n1754 0.188
R4239 VGND.n1797 VGND.n1753 0.188
R4240 VGND.n1798 VGND.n1752 0.188
R4241 VGND.n1788 VGND.n1750 0.188
R4242 VGND.n1802 VGND.n1749 0.188
R4243 VGND.n1803 VGND.n1748 0.188
R4244 VGND.n1804 VGND.n1747 0.188
R4245 VGND.n1785 VGND.n1745 0.188
R4246 VGND.n1808 VGND.n1744 0.188
R4247 VGND.n1809 VGND.n1743 0.188
R4248 VGND.n1810 VGND.n1742 0.188
R4249 VGND.n1757 VGND.n1740 0.188
R4250 VGND.n1814 VGND.n1739 0.188
R4251 VGND.n1815 VGND.n1738 0.188
R4252 VGND.n1816 VGND.n1737 0.188
R4253 VGND.n1782 VGND.n1735 0.188
R4254 VGND.n1820 VGND.n1734 0.188
R4255 VGND.n1821 VGND.n1733 0.188
R4256 VGND.n1822 VGND.n1732 0.188
R4257 VGND.n1779 VGND.n1730 0.188
R4258 VGND.n1826 VGND.n1729 0.188
R4259 VGND.n1827 VGND.n1728 0.188
R4260 VGND.n1828 VGND.n1727 0.188
R4261 VGND.n1758 VGND.n1725 0.188
R4262 VGND.n1832 VGND.n1724 0.188
R4263 VGND.n1833 VGND.n1723 0.188
R4264 VGND.n1834 VGND.n1722 0.188
R4265 VGND.n1776 VGND.n1720 0.188
R4266 VGND.n1838 VGND.n1719 0.188
R4267 VGND.n1839 VGND.n1718 0.188
R4268 VGND.n1840 VGND.n1717 0.188
R4269 VGND.n1773 VGND.n1715 0.188
R4270 VGND.n1844 VGND.n1714 0.188
R4271 VGND.n1845 VGND.n1713 0.188
R4272 VGND.n1846 VGND.n1712 0.188
R4273 VGND.n1759 VGND.n1710 0.188
R4274 VGND.n1850 VGND.n1709 0.188
R4275 VGND.n1851 VGND.n1708 0.188
R4276 VGND.n1852 VGND.n1707 0.188
R4277 VGND.n1770 VGND.n1705 0.188
R4278 VGND.n1856 VGND.n1704 0.188
R4279 VGND.n1857 VGND.n1703 0.188
R4280 VGND.n1858 VGND.n1702 0.188
R4281 VGND.n1767 VGND.n1700 0.188
R4282 VGND.n1862 VGND.n1699 0.188
R4283 VGND.n1863 VGND.n1698 0.188
R4284 VGND.n1864 VGND.n1697 0.188
R4285 VGND.n1760 VGND.n1695 0.188
R4286 VGND.n1868 VGND.n1694 0.188
R4287 VGND.n1869 VGND.n1693 0.188
R4288 VGND.n1870 VGND.n1692 0.188
R4289 VGND.n1764 VGND.n1690 0.188
R4290 VGND.n1874 VGND.n1689 0.188
R4291 VGND.n1875 VGND.n1688 0.188
R4292 VGND.n1876 VGND.n1687 0.188
R4293 VGND.n1761 VGND.n1685 0.188
R4294 VGND.n1880 VGND.n1684 0.188
R4295 VGND.n1881 VGND.n1683 0.188
R4296 VGND.n2069 VGND.n2068 0.188
R4297 VGND.n306 VGND.n378 0.188
R4298 VGND.n1791 VGND.n1790 0.188
R4299 VGND.n304 VGND.n1756 0.188
R4300 VGND.n305 VGND.n1754 0.188
R4301 VGND.n1789 VGND.n1753 0.188
R4302 VGND.n350 VGND.n1752 0.188
R4303 VGND.n351 VGND.n1788 0.188
R4304 VGND.n1787 VGND.n1749 0.188
R4305 VGND.n301 VGND.n1748 0.188
R4306 VGND.n302 VGND.n1747 0.188
R4307 VGND.n1786 VGND.n1785 0.188
R4308 VGND.n352 VGND.n1744 0.188
R4309 VGND.n353 VGND.n1743 0.188
R4310 VGND.n1784 VGND.n1742 0.188
R4311 VGND.n298 VGND.n1757 0.188
R4312 VGND.n299 VGND.n1739 0.188
R4313 VGND.n1783 VGND.n1738 0.188
R4314 VGND.n354 VGND.n1737 0.188
R4315 VGND.n355 VGND.n1782 0.188
R4316 VGND.n1781 VGND.n1734 0.188
R4317 VGND.n295 VGND.n1733 0.188
R4318 VGND.n296 VGND.n1732 0.188
R4319 VGND.n1780 VGND.n1779 0.188
R4320 VGND.n356 VGND.n1729 0.188
R4321 VGND.n357 VGND.n1728 0.188
R4322 VGND.n1778 VGND.n1727 0.188
R4323 VGND.n292 VGND.n1758 0.188
R4324 VGND.n293 VGND.n1724 0.188
R4325 VGND.n1777 VGND.n1723 0.188
R4326 VGND.n358 VGND.n1722 0.188
R4327 VGND.n359 VGND.n1776 0.188
R4328 VGND.n1775 VGND.n1719 0.188
R4329 VGND.n289 VGND.n1718 0.188
R4330 VGND.n290 VGND.n1717 0.188
R4331 VGND.n1774 VGND.n1773 0.188
R4332 VGND.n360 VGND.n1714 0.188
R4333 VGND.n361 VGND.n1713 0.188
R4334 VGND.n1772 VGND.n1712 0.188
R4335 VGND.n286 VGND.n1759 0.188
R4336 VGND.n287 VGND.n1709 0.188
R4337 VGND.n1771 VGND.n1708 0.188
R4338 VGND.n362 VGND.n1707 0.188
R4339 VGND.n363 VGND.n1770 0.188
R4340 VGND.n1769 VGND.n1704 0.188
R4341 VGND.n283 VGND.n1703 0.188
R4342 VGND.n284 VGND.n1702 0.188
R4343 VGND.n1768 VGND.n1767 0.188
R4344 VGND.n364 VGND.n1699 0.188
R4345 VGND.n365 VGND.n1698 0.188
R4346 VGND.n1766 VGND.n1697 0.188
R4347 VGND.n280 VGND.n1760 0.188
R4348 VGND.n281 VGND.n1694 0.188
R4349 VGND.n1765 VGND.n1693 0.188
R4350 VGND.n366 VGND.n1692 0.188
R4351 VGND.n367 VGND.n1764 0.188
R4352 VGND.n1763 VGND.n1689 0.188
R4353 VGND.n277 VGND.n1688 0.188
R4354 VGND.n278 VGND.n1687 0.188
R4355 VGND.n1762 VGND.n1761 0.188
R4356 VGND.n368 VGND.n1684 0.188
R4357 VGND.n369 VGND.n1683 0.188
R4358 VGND.n1682 VGND.n128 0.189565
R4359 VGND.n129 VGND.n128 0.0942177
R4360 VGND.n276 VGND.n368 0.00206464
R4361 VGND.n276 VGND.n129 0.0942177
R4362 VGND.n127 VGND.n278 0.00206464
R4363 VGND.n129 VGND.n127 0.0942177
R4364 VGND.n1763 VGND.n126 0.00206464
R4365 VGND.n129 VGND.n126 0.0942177
R4366 VGND.n279 VGND.n366 0.00206464
R4367 VGND.n279 VGND.n129 0.0942177
R4368 VGND.n124 VGND.n281 0.00206464
R4369 VGND.n129 VGND.n124 0.0942177
R4370 VGND.n1766 VGND.n125 0.00206464
R4371 VGND.n129 VGND.n125 0.0942177
R4372 VGND.n282 VGND.n364 0.00206464
R4373 VGND.n282 VGND.n129 0.0942177
R4374 VGND.n121 VGND.n284 0.00206464
R4375 VGND.n129 VGND.n121 0.0942177
R4376 VGND.n1769 VGND.n122 0.00206464
R4377 VGND.n129 VGND.n122 0.0942177
R4378 VGND.n285 VGND.n362 0.00206464
R4379 VGND.n285 VGND.n129 0.0942177
R4380 VGND.n120 VGND.n287 0.00206464
R4381 VGND.n129 VGND.n120 0.0942177
R4382 VGND.n1772 VGND.n117 0.00206464
R4383 VGND.n129 VGND.n117 0.0942177
R4384 VGND.n288 VGND.n360 0.00206464
R4385 VGND.n288 VGND.n129 0.0942177
R4386 VGND.n118 VGND.n290 0.00206464
R4387 VGND.n129 VGND.n118 0.0942177
R4388 VGND.n1775 VGND.n119 0.00206464
R4389 VGND.n129 VGND.n119 0.0942177
R4390 VGND.n291 VGND.n358 0.00206464
R4391 VGND.n291 VGND.n129 0.0942177
R4392 VGND.n111 VGND.n293 0.00206464
R4393 VGND.n129 VGND.n111 0.0942177
R4394 VGND.n1778 VGND.n110 0.00206464
R4395 VGND.n129 VGND.n110 0.0942177
R4396 VGND.n294 VGND.n356 0.00206464
R4397 VGND.n294 VGND.n129 0.0942177
R4398 VGND.n108 VGND.n296 0.00206464
R4399 VGND.n129 VGND.n108 0.0942177
R4400 VGND.n1781 VGND.n107 0.00206464
R4401 VGND.n129 VGND.n107 0.0942177
R4402 VGND.n297 VGND.n354 0.00206464
R4403 VGND.n297 VGND.n129 0.0942177
R4404 VGND.n109 VGND.n299 0.00206464
R4405 VGND.n129 VGND.n109 0.0942177
R4406 VGND.n1784 VGND.n112 0.00206464
R4407 VGND.n129 VGND.n112 0.0942177
R4408 VGND.n300 VGND.n352 0.00206464
R4409 VGND.n300 VGND.n129 0.0942177
R4410 VGND.n113 VGND.n302 0.00206464
R4411 VGND.n129 VGND.n113 0.0942177
R4412 VGND.n1787 VGND.n114 0.00206464
R4413 VGND.n129 VGND.n114 0.0942177
R4414 VGND.n303 VGND.n350 0.00206464
R4415 VGND.n303 VGND.n129 0.0942177
R4416 VGND.n116 VGND.n305 0.00206464
R4417 VGND.n129 VGND.n116 0.0942177
R4418 VGND.n1790 VGND.n115 0.00206464
R4419 VGND.n129 VGND.n115 0.0942177
R4420 VGND.n2068 VGND.n129 0.188
R4421 VGND.n1364 VGND.n129 0.188
R4422 VGND.n129 VGND.n81 0.0942177
R4423 VGND.n81 VGND.n274 0.00206464
R4424 VGND.n272 VGND.n129 0.0942177
R4425 VGND.n272 VGND.n372 0.00206464
R4426 VGND.n271 VGND.n129 0.0942177
R4427 VGND.n271 VGND.n373 0.00206464
R4428 VGND.n129 VGND.n80 0.0942177
R4429 VGND.n80 VGND.n270 0.00206464
R4430 VGND.n264 VGND.n129 0.0942177
R4431 VGND.n264 VGND.n370 0.00206464
R4432 VGND.n129 VGND.n79 0.0942177
R4433 VGND.n1392 VGND.n79 0.00206464
R4434 VGND.n275 VGND.n371 0.00206464
R4435 VGND.n275 VGND.n129 0.0942177
R4436 VGND.n129 VGND.n77 0.0942177
R4437 VGND.n77 VGND.n266 0.00206464
R4438 VGND.n129 VGND.n78 0.188
R4439 VGND.n1402 VGND.n76 0.00206464
R4440 VGND.n129 VGND.n76 0.0942177
R4441 VGND.n309 VGND.n348 0.00206464
R4442 VGND.n309 VGND.n129 0.0942177
R4443 VGND.n129 VGND.n75 0.188
R4444 VGND.n1414 VGND.n74 0.00206464
R4445 VGND.n129 VGND.n74 0.0942177
R4446 VGND.n129 VGND.n73 0.0942177
R4447 VGND.n73 VGND.n267 0.00206464
R4448 VGND.n1473 VGND.n129 0.188
R4449 VGND.n72 VGND.n269 0.00206464
R4450 VGND.n129 VGND.n72 0.0942177
R4451 VGND.n1483 VGND.n71 0.00206464
R4452 VGND.n129 VGND.n71 0.0942177
R4453 VGND.n1484 VGND.n70 0.00206464
R4454 VGND.n129 VGND.n70 0.0942177
R4455 VGND.n311 VGND.n347 0.00206464
R4456 VGND.n311 VGND.n129 0.0942177
R4457 VGND.n313 VGND.n345 0.00206464
R4458 VGND.n313 VGND.n129 0.0942177
R4459 VGND.n69 VGND.n315 0.00206464
R4460 VGND.n129 VGND.n69 0.0942177
R4461 VGND.n1505 VGND.n89 0.00206464
R4462 VGND.n129 VGND.n89 0.0942177
R4463 VGND.n1506 VGND.n90 0.00206464
R4464 VGND.n129 VGND.n90 0.0942177
R4465 VGND.n321 VGND.n340 0.00206464
R4466 VGND.n321 VGND.n129 0.0942177
R4467 VGND.n324 VGND.n339 0.00206464
R4468 VGND.n324 VGND.n129 0.0942177
R4469 VGND.n88 VGND.n325 0.00206464
R4470 VGND.n129 VGND.n88 0.0942177
R4471 VGND.n1527 VGND.n87 0.00206464
R4472 VGND.n129 VGND.n87 0.0942177
R4473 VGND.n1528 VGND.n129 0.188
R4474 VGND.n85 VGND.n330 0.00206464
R4475 VGND.n129 VGND.n85 0.0942177
R4476 VGND.n1538 VGND.n129 0.188
R4477 VGND.n129 VGND.n86 0.0942177
R4478 VGND.n1539 VGND.n86 0.00206464
R4479 VGND.n129 VGND.n84 0.0942177
R4480 VGND.n84 VGND.n332 0.00206464
R4481 VGND.n329 VGND.n129 0.0942177
R4482 VGND.n329 VGND.n335 0.00206464
R4483 VGND.n1549 VGND.n129 0.188
R4484 VGND.n129 VGND.n83 0.188
R4485 VGND.n312 VGND.n346 0.00206464
R4486 VGND.n312 VGND.n129 0.0942177
R4487 VGND.n314 VGND.n344 0.00206464
R4488 VGND.n314 VGND.n129 0.0942177
R4489 VGND.n91 VGND.n316 0.00206464
R4490 VGND.n129 VGND.n91 0.0942177
R4491 VGND.n1571 VGND.n92 0.00206464
R4492 VGND.n129 VGND.n92 0.0942177
R4493 VGND.n1572 VGND.n93 0.00206464
R4494 VGND.n129 VGND.n93 0.0942177
R4495 VGND.n94 VGND.n323 0.00206464
R4496 VGND.n129 VGND.n94 0.0942177
R4497 VGND.n262 VGND.n129 0.0942177
R4498 VGND.n262 VGND.n338 0.00206464
R4499 VGND.n326 VGND.n336 0.00206464
R4500 VGND.n326 VGND.n129 0.0942177
R4501 VGND.n129 VGND.n95 0.188
R4502 VGND.n328 VGND.n129 0.0942177
R4503 VGND.n328 VGND.n692 0.00206464
R4504 VGND.n96 VGND.n246 0.00206464
R4505 VGND.n129 VGND.n96 0.0942177
R4506 VGND.n241 VGND.n129 0.0942177
R4507 VGND.n241 VGND.n686 0.00206464
R4508 VGND.n129 VGND.n97 0.0942177
R4509 VGND.n97 VGND.n237 0.00206464
R4510 VGND.n1607 VGND.n98 0.00206464
R4511 VGND.n129 VGND.n98 0.0942177
R4512 VGND.n99 VGND.n231 0.00206464
R4513 VGND.n129 VGND.n99 0.0942177
R4514 VGND.n1615 VGND.n82 0.00206464
R4515 VGND.n129 VGND.n82 0.0942177
R4516 VGND.n106 VGND.n223 0.00206464
R4517 VGND.n129 VGND.n106 0.0942177
R4518 VGND.n226 VGND.n129 0.0942177
R4519 VGND.n226 VGND.n227 0.00206464
R4520 VGND.n101 VGND.n233 0.00206464
R4521 VGND.n129 VGND.n101 0.0942177
R4522 VGND.n235 VGND.n129 0.0942177
R4523 VGND.n235 VGND.n236 0.00206464
R4524 VGND.n102 VGND.n243 0.00206464
R4525 VGND.n129 VGND.n102 0.0942177
R4526 VGND.n247 VGND.n129 0.0942177
R4527 VGND.n247 VGND.n250 0.00206464
R4528 VGND.n129 VGND.n104 0.0942177
R4529 VGND.n104 VGND.n254 0.00206464
R4530 VGND.n256 VGND.n129 0.0942177
R4531 VGND.n256 VGND.n257 0.00206464
R4532 VGND.n129 VGND.n105 0.0942177
R4533 VGND.n105 VGND.n258 0.00206464
R4534 VGND.n1661 VGND.n263 0.00206464
R4535 VGND.n263 VGND.n129 0.0942177
R4536 VGND.n259 VGND.n129 0.0942177
R4537 VGND.n259 VGND.n1889 0.00206464
R4538 VGND.n1888 VGND.n103 0.00206464
R4539 VGND.n129 VGND.n103 0.0942177
R4540 VGND.n240 VGND.n244 0.00206464
R4541 VGND.n240 VGND.n129 0.0942177
R4542 VGND.n129 VGND.n100 0.0942177
R4543 VGND.n100 VGND.n229 0.00206464
R4544 VGND.n1886 VGND.n129 0.188
R4545 VGND.n129 VGND.n123 0.0942177
R4546 VGND.n1553 VGND.n83 0.188
R4547 VGND.n123 VGND.n249 0.189565
R4548 VGND.n645 VGND.n248 0.188
R4549 VGND.n1886 VGND.n644 0.188
R4550 VGND.n229 VGND.n643 0.188
R4551 VGND.n649 VGND.n228 0.188
R4552 VGND.n1887 VGND.n642 0.188
R4553 VGND.n244 VGND.n641 0.188
R4554 VGND.n1670 VGND.n251 0.188
R4555 VGND.n1888 VGND.n640 0.188
R4556 VGND.n1889 VGND.n639 0.188
R4557 VGND.n1664 VGND.n638 0.188
R4558 VGND.n1663 VGND.n1662 0.188
R4559 VGND.n1661 VGND.n654 0.188
R4560 VGND.n1658 VGND.n258 0.188
R4561 VGND.n1660 VGND.n1659 0.188
R4562 VGND.n655 VGND.n257 0.188
R4563 VGND.n1650 VGND.n1649 0.188
R4564 VGND.n254 VGND.n660 0.188
R4565 VGND.n1648 VGND.n1647 0.188
R4566 VGND.n661 VGND.n250 0.188
R4567 VGND.n1640 VGND.n1639 0.188
R4568 VGND.n242 VGND.n665 0.188
R4569 VGND.n243 VGND.n1638 0.188
R4570 VGND.n666 VGND.n236 0.188
R4571 VGND.n1632 VGND.n1631 0.188
R4572 VGND.n232 VGND.n670 0.188
R4573 VGND.n233 VGND.n1630 0.188
R4574 VGND.n671 VGND.n227 0.188
R4575 VGND.n1624 VGND.n1623 0.188
R4576 VGND.n222 VGND.n675 0.188
R4577 VGND.n223 VGND.n1622 0.188
R4578 VGND.n676 VGND.n225 0.188
R4579 VGND.n1616 VGND.n1615 0.188
R4580 VGND.n230 VGND.n680 0.188
R4581 VGND.n231 VGND.n1614 0.188
R4582 VGND.n681 VGND.n234 0.188
R4583 VGND.n1608 VGND.n1607 0.188
R4584 VGND.n237 VGND.n685 0.188
R4585 VGND.n239 VGND.n1606 0.188
R4586 VGND.n687 VGND.n686 0.188
R4587 VGND.n1600 VGND.n1599 0.188
R4588 VGND.n245 VGND.n691 0.188
R4589 VGND.n246 VGND.n1598 0.188
R4590 VGND.n693 VGND.n692 0.188
R4591 VGND.n1592 VGND.n1591 0.188
R4592 VGND.n95 VGND.n697 0.188
R4593 VGND.n1590 VGND.n1589 0.188
R4594 VGND.n336 VGND.n698 0.188
R4595 VGND.n1583 VGND.n338 0.188
R4596 VGND.n1582 VGND.n1581 0.188
R4597 VGND.n322 VGND.n702 0.188
R4598 VGND.n323 VGND.n1580 0.188
R4599 VGND.n703 VGND.n320 0.188
R4600 VGND.n1573 VGND.n1572 0.188
R4601 VGND.n318 VGND.n708 0.188
R4602 VGND.n1571 VGND.n1570 0.188
R4603 VGND.n342 VGND.n709 0.188
R4604 VGND.n1564 VGND.n316 0.188
R4605 VGND.n1563 VGND.n1562 0.188
R4606 VGND.n344 VGND.n713 0.188
R4607 VGND.n1561 VGND.n1560 0.188
R4608 VGND.n346 VGND.n714 0.188
R4609 VGND.n1554 VGND.n1553 0.188
R4610 VGND.n249 VGND.n1885 0.188
R4611 VGND.n646 VGND.n645 0.188
R4612 VGND.n1678 VGND.n644 0.188
R4613 VGND.n1677 VGND.n643 0.188
R4614 VGND.n1676 VGND.n649 0.188
R4615 VGND.n648 VGND.n642 0.188
R4616 VGND.n1672 VGND.n641 0.188
R4617 VGND.n1671 VGND.n1670 0.188
R4618 VGND.n1669 VGND.n640 0.188
R4619 VGND.n651 VGND.n639 0.188
R4620 VGND.n1665 VGND.n1664 0.188
R4621 VGND.n1663 VGND.n653 0.188
R4622 VGND.n657 VGND.n654 0.188
R4623 VGND.n1658 VGND.n1657 0.188
R4624 VGND.n1659 VGND.n656 0.188
R4625 VGND.n1652 VGND.n655 0.188
R4626 VGND.n1651 VGND.n1650 0.188
R4627 VGND.n660 VGND.n659 0.188
R4628 VGND.n1647 VGND.n1646 0.188
R4629 VGND.n662 VGND.n661 0.188
R4630 VGND.n1641 VGND.n1640 0.188
R4631 VGND.n665 VGND.n664 0.188
R4632 VGND.n1638 VGND.n1637 0.188
R4633 VGND.n667 VGND.n666 0.188
R4634 VGND.n1633 VGND.n1632 0.188
R4635 VGND.n670 VGND.n669 0.188
R4636 VGND.n1630 VGND.n1629 0.188
R4637 VGND.n672 VGND.n671 0.188
R4638 VGND.n1625 VGND.n1624 0.188
R4639 VGND.n675 VGND.n674 0.188
R4640 VGND.n1622 VGND.n1621 0.188
R4641 VGND.n677 VGND.n676 0.188
R4642 VGND.n1617 VGND.n1616 0.188
R4643 VGND.n680 VGND.n679 0.188
R4644 VGND.n1614 VGND.n1613 0.188
R4645 VGND.n682 VGND.n681 0.188
R4646 VGND.n1609 VGND.n1608 0.188
R4647 VGND.n685 VGND.n684 0.188
R4648 VGND.n1606 VGND.n1605 0.188
R4649 VGND.n688 VGND.n687 0.188
R4650 VGND.n1601 VGND.n1600 0.188
R4651 VGND.n691 VGND.n690 0.188
R4652 VGND.n1598 VGND.n1597 0.188
R4653 VGND.n694 VGND.n693 0.188
R4654 VGND.n1593 VGND.n1592 0.188
R4655 VGND.n697 VGND.n696 0.188
R4656 VGND.n1589 VGND.n1588 0.188
R4657 VGND.n699 VGND.n698 0.188
R4658 VGND.n1584 VGND.n1583 0.188
R4659 VGND.n1582 VGND.n701 0.188
R4660 VGND.n705 VGND.n702 0.188
R4661 VGND.n1580 VGND.n1579 0.188
R4662 VGND.n704 VGND.n703 0.188
R4663 VGND.n1574 VGND.n1573 0.188
R4664 VGND.n708 VGND.n707 0.188
R4665 VGND.n1570 VGND.n1569 0.188
R4666 VGND.n710 VGND.n709 0.188
R4667 VGND.n1565 VGND.n1564 0.188
R4668 VGND.n1563 VGND.n712 0.188
R4669 VGND.n716 VGND.n713 0.188
R4670 VGND.n1560 VGND.n1559 0.188
R4671 VGND.n715 VGND.n714 0.188
R4672 VGND.n1365 VGND.n1364 0.188
R4673 VGND.n1550 VGND.n1549 0.188
R4674 VGND.n335 VGND.n719 0.188
R4675 VGND.n1548 VGND.n1547 0.188
R4676 VGND.n332 VGND.n720 0.188
R4677 VGND.n1541 VGND.n331 0.188
R4678 VGND.n1540 VGND.n1539 0.188
R4679 VGND.n333 VGND.n724 0.188
R4680 VGND.n1538 VGND.n1537 0.188
R4681 VGND.n334 VGND.n725 0.188
R4682 VGND.n1530 VGND.n330 0.188
R4683 VGND.n1529 VGND.n1528 0.188
R4684 VGND.n327 VGND.n730 0.188
R4685 VGND.n1527 VGND.n1526 0.188
R4686 VGND.n337 VGND.n731 0.188
R4687 VGND.n1519 VGND.n325 0.188
R4688 VGND.n1518 VGND.n1517 0.188
R4689 VGND.n339 VGND.n736 0.188
R4690 VGND.n1516 VGND.n1515 0.188
R4691 VGND.n340 VGND.n737 0.188
R4692 VGND.n1508 VGND.n319 0.188
R4693 VGND.n1507 VGND.n1506 0.188
R4694 VGND.n317 VGND.n742 0.188
R4695 VGND.n1505 VGND.n1504 0.188
R4696 VGND.n343 VGND.n743 0.188
R4697 VGND.n1497 VGND.n315 0.188
R4698 VGND.n1496 VGND.n1495 0.188
R4699 VGND.n345 VGND.n748 0.188
R4700 VGND.n1494 VGND.n1493 0.188
R4701 VGND.n347 VGND.n749 0.188
R4702 VGND.n1486 VGND.n310 0.188
R4703 VGND.n1485 VGND.n1484 0.188
R4704 VGND.n308 VGND.n754 0.188
R4705 VGND.n1483 VGND.n1482 0.188
R4706 VGND.n341 VGND.n755 0.188
R4707 VGND.n1475 VGND.n269 0.188
R4708 VGND.n1474 VGND.n1473 0.188
R4709 VGND.n267 VGND.n760 0.188
R4710 VGND.n349 VGND.n1422 0.188
R4711 VGND.n789 VGND.n307 0.188
R4712 VGND.n1415 VGND.n1414 0.188
R4713 VGND.n75 VGND.n794 0.188
R4714 VGND.n1411 VGND.n1410 0.188
R4715 VGND.n348 VGND.n799 0.188
R4716 VGND.n1404 VGND.n268 0.188
R4717 VGND.n1403 VGND.n1402 0.188
R4718 VGND.n78 VGND.n803 0.188
R4719 VGND.n266 VGND.n1401 0.188
R4720 VGND.n808 VGND.n265 0.188
R4721 VGND.n1394 VGND.n1393 0.188
R4722 VGND.n371 VGND.n813 0.188
R4723 VGND.n1392 VGND.n1391 0.188
R4724 VGND.n374 VGND.n818 0.188
R4725 VGND.n1385 VGND.n370 0.188
R4726 VGND.n1384 VGND.n1383 0.188
R4727 VGND.n270 VGND.n822 0.188
R4728 VGND.n375 VGND.n1382 0.188
R4729 VGND.n823 VGND.n373 0.188
R4730 VGND.n1375 VGND.n1374 0.188
R4731 VGND.n372 VGND.n828 0.188
R4732 VGND.n1373 VGND.n1372 0.188
R4733 VGND.n274 VGND.n829 0.188
R4734 VGND.n1366 VGND.n273 0.188
R4735 VGND.n1551 VGND.n1550 0.188
R4736 VGND.n719 VGND.n718 0.188
R4737 VGND.n1547 VGND.n1546 0.188
R4738 VGND.n721 VGND.n720 0.188
R4739 VGND.n1542 VGND.n1541 0.188
R4740 VGND.n1540 VGND.n723 0.188
R4741 VGND.n727 VGND.n724 0.188
R4742 VGND.n1537 VGND.n1536 0.188
R4743 VGND.n726 VGND.n725 0.188
R4744 VGND.n1531 VGND.n1530 0.188
R4745 VGND.n1529 VGND.n729 0.188
R4746 VGND.n733 VGND.n730 0.188
R4747 VGND.n1526 VGND.n1525 0.188
R4748 VGND.n732 VGND.n731 0.188
R4749 VGND.n1520 VGND.n1519 0.188
R4750 VGND.n1518 VGND.n735 0.188
R4751 VGND.n739 VGND.n736 0.188
R4752 VGND.n1515 VGND.n1514 0.188
R4753 VGND.n738 VGND.n737 0.188
R4754 VGND.n1509 VGND.n1508 0.188
R4755 VGND.n1507 VGND.n741 0.188
R4756 VGND.n745 VGND.n742 0.188
R4757 VGND.n1504 VGND.n1503 0.188
R4758 VGND.n744 VGND.n743 0.188
R4759 VGND.n1498 VGND.n1497 0.188
R4760 VGND.n1496 VGND.n747 0.188
R4761 VGND.n751 VGND.n748 0.188
R4762 VGND.n1493 VGND.n1492 0.188
R4763 VGND.n750 VGND.n749 0.188
R4764 VGND.n1487 VGND.n1486 0.188
R4765 VGND.n1485 VGND.n753 0.188
R4766 VGND.n757 VGND.n754 0.188
R4767 VGND.n1482 VGND.n1481 0.188
R4768 VGND.n756 VGND.n755 0.188
R4769 VGND.n1476 VGND.n1475 0.188
R4770 VGND.n1474 VGND.n759 0.188
R4771 VGND.n791 VGND.n760 0.188
R4772 VGND.n1422 VGND.n1421 0.188
R4773 VGND.n790 VGND.n789 0.188
R4774 VGND.n1416 VGND.n1415 0.188
R4775 VGND.n794 VGND.n793 0.188
R4776 VGND.n1410 VGND.n1409 0.188
R4777 VGND.n800 VGND.n799 0.188
R4778 VGND.n1405 VGND.n1404 0.188
R4779 VGND.n1403 VGND.n802 0.188
R4780 VGND.n810 VGND.n803 0.188
R4781 VGND.n1401 VGND.n1400 0.188
R4782 VGND.n809 VGND.n808 0.188
R4783 VGND.n1395 VGND.n1394 0.188
R4784 VGND.n813 VGND.n812 0.188
R4785 VGND.n1391 VGND.n1390 0.188
R4786 VGND.n819 VGND.n818 0.188
R4787 VGND.n1386 VGND.n1385 0.188
R4788 VGND.n1384 VGND.n821 0.188
R4789 VGND.n825 VGND.n822 0.188
R4790 VGND.n1382 VGND.n1381 0.188
R4791 VGND.n824 VGND.n823 0.188
R4792 VGND.n1376 VGND.n1375 0.188
R4793 VGND.n828 VGND.n827 0.188
R4794 VGND.n1372 VGND.n1371 0.188
R4795 VGND.n830 VGND.n829 0.188
R4796 VGND.n1367 VGND.n1366 0.188
R4797 VGND.n155 VGND.n162 0.146822
R4798 VGND.n131 VGND.n163 0.146822
R4799 VGND.n1430 VGND.n1429 0.129406
R4800 VGND.n1472 VGND.n1471 0.119517
R4801 VGND.n1429 VGND.n1428 0.1105
R4802 VGND.n1138 VGND.t52 0.109869
R4803 VGND.n1369 VGND.n1368 0.0968914
R4804 VGND.n2 VGND.n1 0.00903495
R4805 VGND.t9 VGND.n224 0.0348862
R4806 VGND.n1197 VGND.n47 0.568275
R4807 VGND.n1190 VGND.n1177 0.0595769
R4808 VGND.n1180 VGND.n1177 0.0595769
R4809 VGND.n1191 VGND.n1176 0.0595769
R4810 VGND.n1181 VGND.n1176 0.0595769
R4811 VGND.n1186 VGND.n1181 0.0595769
R4812 VGND.n1192 VGND.n1175 0.0595769
R4813 VGND.n1184 VGND.n1175 0.0595769
R4814 VGND.n1185 VGND.n1184 0.0595769
R4815 VGND.n1425 VGND.n48 0.0570278
R4816 VGND.t3 VGND.n0 0.625125
R4817 VGND.n154 VGND.n152 0.170277
R4818 VGND.n152 VGND.n150 0.226262
R4819 VGND.n150 VGND.n148 0.226262
R4820 VGND.n148 VGND.n146 0.226262
R4821 VGND.n146 VGND.n144 0.226262
R4822 VGND.n144 VGND.n142 0.226262
R4823 VGND.n142 VGND.n140 0.226262
R4824 VGND.n140 VGND.n138 0.226262
R4825 VGND.n138 VGND.n136 0.226262
R4826 VGND.n136 VGND.n134 0.226262
R4827 VGND.n134 VGND.n132 0.253313
R4828 VGND.n165 VGND.n132 0.253296
R4829 VGND.n167 VGND.n165 0.226262
R4830 VGND.n169 VGND.n167 0.226262
R4831 VGND.n170 VGND.n169 0.226262
R4832 VGND.n54 VGND.n170 0.279766
R4833 VGND.n54 VGND.n1229 0.192387
R4834 VGND.n1232 VGND.n1229 0.0555
R4835 VGND.n1233 VGND.n1232 0.0555
R4836 VGND.n1234 VGND.n1233 0.0555
R4837 VGND.n1234 VGND.n879 0.0555
R4838 VGND.n1238 VGND.n879 0.0555
R4839 VGND.n1239 VGND.n1238 0.0555
R4840 VGND.n1240 VGND.n1239 0.0555
R4841 VGND.n1240 VGND.n875 0.0555
R4842 VGND.n1245 VGND.n875 0.0555
R4843 VGND.n1246 VGND.n1245 0.0555
R4844 VGND.n1247 VGND.n1246 0.0555
R4845 VGND.n1247 VGND.n872 0.0555
R4846 VGND.n1252 VGND.n872 0.0555
R4847 VGND.n1253 VGND.n1252 0.0555
R4848 VGND.n1253 VGND.n870 0.0555
R4849 VGND.n1257 VGND.n870 0.0555
R4850 VGND.n1258 VGND.n1257 0.0555
R4851 VGND.n1259 VGND.n1258 0.0555
R4852 VGND.n1259 VGND.n868 0.0555
R4853 VGND.n1263 VGND.n868 0.0555
R4854 VGND.n1264 VGND.n1263 0.0555
R4855 VGND.n1265 VGND.n1264 0.0555
R4856 VGND.n1265 VGND.n866 0.0555
R4857 VGND.n1269 VGND.n866 0.0555
R4858 VGND.n1270 VGND.n1269 0.0555
R4859 VGND.n1271 VGND.n1270 0.0555
R4860 VGND.n1271 VGND.n864 0.0555
R4861 VGND.n1275 VGND.n864 0.0555
R4862 VGND.n1276 VGND.n1275 0.0555
R4863 VGND.n1277 VGND.n1276 0.0555
R4864 VGND.n1277 VGND.n862 0.0555
R4865 VGND.n1281 VGND.n862 0.0555
R4866 VGND.n1282 VGND.n1281 0.0555
R4867 VGND.n1283 VGND.n1282 0.0555
R4868 VGND.n1283 VGND.n860 0.0555
R4869 VGND.n1287 VGND.n860 0.0555
R4870 VGND.n1288 VGND.n1287 0.0555
R4871 VGND.n1289 VGND.n1288 0.0555
R4872 VGND.n1289 VGND.n858 0.0555
R4873 VGND.n1293 VGND.n858 0.0555
R4874 VGND.n1294 VGND.n1293 0.0555
R4875 VGND.n1295 VGND.n1294 0.0555
R4876 VGND.n1295 VGND.n856 0.0555
R4877 VGND.n1299 VGND.n856 0.0555
R4878 VGND.n1300 VGND.n1299 0.0555
R4879 VGND.n1301 VGND.n1300 0.0555
R4880 VGND.n1301 VGND.n854 0.0555
R4881 VGND.n1305 VGND.n854 0.0555
R4882 VGND.n1306 VGND.n1305 0.0555
R4883 VGND.n1307 VGND.n1306 0.0555
R4884 VGND.n1307 VGND.n852 0.0555
R4885 VGND.n1311 VGND.n852 0.0555
R4886 VGND.n1312 VGND.n1311 0.0555
R4887 VGND.n1313 VGND.n1312 0.0555
R4888 VGND.n1313 VGND.n850 0.0555
R4889 VGND.n1317 VGND.n850 0.0555
R4890 VGND.n1318 VGND.n1317 0.0555
R4891 VGND.n1319 VGND.n1318 0.0555
R4892 VGND.n1319 VGND.n848 0.0555
R4893 VGND.n1323 VGND.n848 0.0555
R4894 VGND.n1324 VGND.n1323 0.0555
R4895 VGND.n1325 VGND.n1324 0.0555
R4896 VGND.n1325 VGND.n846 0.0555
R4897 VGND.n1329 VGND.n846 0.0555
R4898 VGND.n1330 VGND.n1329 0.0555
R4899 VGND.n1331 VGND.n1330 0.0555
R4900 VGND.n1331 VGND.n844 0.0555
R4901 VGND.n1335 VGND.n844 0.0555
R4902 VGND.n1336 VGND.n1335 0.0555
R4903 VGND.n1337 VGND.n1336 0.0555
R4904 VGND.n1337 VGND.n842 0.0555
R4905 VGND.n1341 VGND.n842 0.0555
R4906 VGND.n1342 VGND.n1341 0.0555
R4907 VGND.n1343 VGND.n1342 0.0555
R4908 VGND.n1343 VGND.n840 0.0555
R4909 VGND.n1347 VGND.n840 0.0555
R4910 VGND.n1348 VGND.n1347 0.0555
R4911 VGND.n1349 VGND.n1348 0.0555
R4912 VGND.n1349 VGND.n838 0.0555
R4913 VGND.n174 VGND.n838 0.200552
R4914 VGND.n217 VGND.t1 0.083333
R4915 VGND.n527 VGND.n525 0.0539902
R4916 VGND.n2063 VGND.n2034 0.0539902
R4917 VGND.n1427 VGND.n1426 0.0535903
R4918 VGND.n1912 VGND.n602 0.0529549
R4919 VGND.n1954 VGND.n1925 0.0529549
R4920 VGND.n896 VGND.n895 0.0476547
R4921 VGND.n1472 VGND.n48 0.0451875
R4922 VGND.n173 VGND.n172 0.266333
R4923 VGND.n1231 VGND.n1230 0.0445
R4924 VGND.n1231 VGND.n1228 0.0445
R4925 VGND.n1235 VGND.n1228 0.0445
R4926 VGND.n1236 VGND.n1235 0.0445
R4927 VGND.n1237 VGND.n1236 0.0445
R4928 VGND.n1241 VGND.n878 0.0445
R4929 VGND.n1244 VGND.n1243 0.0445
R4930 VGND.n1248 VGND.n874 0.0445
R4931 VGND.n1251 VGND.n1250 0.0445
R4932 VGND.n1255 VGND.n1254 0.0445
R4933 VGND.n1256 VGND.n1255 0.0445
R4934 VGND.n1256 VGND.n869 0.0445
R4935 VGND.n1260 VGND.n869 0.0445
R4936 VGND.n1261 VGND.n1260 0.0445
R4937 VGND.n1262 VGND.n1261 0.0445
R4938 VGND.n1262 VGND.n867 0.0445
R4939 VGND.n1266 VGND.n867 0.0445
R4940 VGND.n1267 VGND.n1266 0.0445
R4941 VGND.n1268 VGND.n1267 0.0445
R4942 VGND.n1268 VGND.n865 0.0445
R4943 VGND.n1272 VGND.n865 0.0445
R4944 VGND.n1273 VGND.n1272 0.0445
R4945 VGND.n1274 VGND.n1273 0.0445
R4946 VGND.n1274 VGND.n863 0.0445
R4947 VGND.n1278 VGND.n863 0.0445
R4948 VGND.n1279 VGND.n1278 0.0445
R4949 VGND.n1280 VGND.n1279 0.0445
R4950 VGND.n1280 VGND.n861 0.0445
R4951 VGND.n1284 VGND.n861 0.0445
R4952 VGND.n1285 VGND.n1284 0.0445
R4953 VGND.n1286 VGND.n1285 0.0445
R4954 VGND.n1286 VGND.n859 0.0445
R4955 VGND.n1290 VGND.n859 0.0445
R4956 VGND.n1291 VGND.n1290 0.0445
R4957 VGND.n1292 VGND.n1291 0.0445
R4958 VGND.n1292 VGND.n857 0.0445
R4959 VGND.n1296 VGND.n857 0.0445
R4960 VGND.n1297 VGND.n1296 0.0445
R4961 VGND.n1298 VGND.n1297 0.0445
R4962 VGND.n1298 VGND.n855 0.0445
R4963 VGND.n1302 VGND.n855 0.0445
R4964 VGND.n1303 VGND.n1302 0.0445
R4965 VGND.n1304 VGND.n1303 0.0445
R4966 VGND.n1304 VGND.n853 0.0445
R4967 VGND.n1308 VGND.n853 0.0445
R4968 VGND.n1309 VGND.n1308 0.0445
R4969 VGND.n1310 VGND.n1309 0.0445
R4970 VGND.n1310 VGND.n851 0.0445
R4971 VGND.n1314 VGND.n851 0.0445
R4972 VGND.n1315 VGND.n1314 0.0445
R4973 VGND.n1316 VGND.n1315 0.0445
R4974 VGND.n1316 VGND.n849 0.0445
R4975 VGND.n1320 VGND.n849 0.0445
R4976 VGND.n1321 VGND.n1320 0.0445
R4977 VGND.n1322 VGND.n1321 0.0445
R4978 VGND.n1322 VGND.n847 0.0445
R4979 VGND.n1326 VGND.n847 0.0445
R4980 VGND.n1327 VGND.n1326 0.0445
R4981 VGND.n1328 VGND.n1327 0.0445
R4982 VGND.n1328 VGND.n845 0.0445
R4983 VGND.n1332 VGND.n845 0.0445
R4984 VGND.n1333 VGND.n1332 0.0445
R4985 VGND.n1334 VGND.n1333 0.0445
R4986 VGND.n1334 VGND.n843 0.0445
R4987 VGND.n1338 VGND.n843 0.0445
R4988 VGND.n1339 VGND.n1338 0.0445
R4989 VGND.n1340 VGND.n1339 0.0445
R4990 VGND.n1340 VGND.n841 0.0445
R4991 VGND.n1344 VGND.n841 0.0445
R4992 VGND.n1345 VGND.n1344 0.0445
R4993 VGND.n1346 VGND.n1345 0.0445
R4994 VGND.n1346 VGND.n839 0.0445
R4995 VGND.n1350 VGND.n839 0.0445
R4996 VGND.n172 VGND.n1350 0.0445
R4997 VGND.n1354 VGND.n832 0.0445
R4998 VGND.n1361 VGND.n832 0.0445
R4999 VGND.n1362 VGND.n1361 0.0445
R5000 VGND.n1362 VGND.n68 0.322817
R5001 VGND.n129 VGND.n68 6.6633
R5002 VGND.n1357 VGND.n1356 0.0440417
R5003 VGND.n1227 VGND.n878 0.0426667
R5004 VGND.n1352 VGND.n1351 0.0400312
R5005 VGND.n1359 VGND.n1358 0.0400312
R5006 VGND.n1243 VGND.n1242 0.0394583
R5007 VGND.n876 VGND.n874 0.0380833
R5008 VGND.n1250 VGND.n1249 0.0380833
R5009 VGND.n1148 VGND.n835 0.0380486
R5010 VGND.n1471 VGND.n1470 0.0370173
R5011 VGND.n1254 VGND.n871 0.0367083
R5012 VGND.n551 VGND.n549 0.0365627
R5013 VGND.n2030 VGND.n1999 0.0365627
R5014 VGND.n1148 VGND.n834 0.0365208
R5015 VGND.n1360 VGND.n831 0.0360208
R5016 VGND.n1149 VGND.n833 0.0357565
R5017 VGND.n1164 VGND.n1163 0.035375
R5018 VGND.n1454 VGND.n1453 0.0352907
R5019 VGND.n580 VGND.n578 0.0351824
R5020 VGND.n1994 VGND.n1958 0.0351824
R5021 VGND.n892 VGND.n884 0.0348284
R5022 VGND.n1160 VGND.n1159 0.0342287
R5023 VGND.n1451 VGND.n1450 0.0337558
R5024 VGND.n774 VGND.n773 0.0336019
R5025 VGND.n882 VGND.n877 0.0329874
R5026 VGND.n1456 VGND.n1455 0.0327326
R5027 VGND.n893 VGND.n885 0.0325272
R5028 VGND.n896 VGND.n881 0.0323194
R5029 VGND.n888 VGND.n886 0.0316067
R5030 VGND.n1449 VGND.n1448 0.0311977
R5031 VGND.n1165 VGND.n1164 0.0307916
R5032 VGND.n1188 VGND.n1187 0.0304418
R5033 VGND.n1188 VGND.n1180 0.0304418
R5034 VGND.n1024 VGND.n42 0.0605947
R5035 VGND.n1458 VGND.n1457 0.0301744
R5036 VGND.n771 VGND.n770 0.030037
R5037 VGND.n1159 VGND.n1157 0.0296458
R5038 VGND.n1024 VGND.n962 0.0292639
R5039 VGND.n1165 VGND.n12 0.0562443
R5040 VGND.n12 VGND.n11 9.1003
R5041 VGND.n1355 VGND.n836 0.0291458
R5042 VGND.n1413 VGND.n775 0.0290185
R5043 VGND.n1090 VGND.n881 0.0288819
R5044 VGND.n1447 VGND.n1446 0.0286395
R5045 VGND.n68 VGND.n67 0.381871
R5046 VGND.n777 VGND.n776 0.0285093
R5047 VGND.n10 VGND.n8 0.0285093
R5048 VGND.n1025 VGND.n1024 0.028
R5049 VGND.n1225 VGND.n881 0.028
R5050 VGND.n1158 VGND.n51 0.028
R5051 VGND.n32 VGND.n50 0.028
R5052 VGND.n1163 VGND.t14 0.028
R5053 VGND.n14 VGND.t12 0.0344739
R5054 VGND.n1156 VGND.n833 0.027736
R5055 VGND.n1460 VGND.n1459 0.0276163
R5056 VGND.n1170 VGND.n1169 0.0272778
R5057 VGND.n0 VGND.n46 0.65333
R5058 VGND.n1156 VGND.n834 0.0269721
R5059 VGND.n1353 VGND.n836 0.0268542
R5060 VGND.n1909 VGND.n1908 0.0264141
R5061 VGND.n1908 VGND.n1907 0.0264141
R5062 VGND.n1907 VGND.n1906 0.0264141
R5063 VGND.n1906 VGND.n1905 0.0264141
R5064 VGND.n430 VGND.n1890 0.0264141
R5065 VGND.n1897 VGND.n1890 0.0264141
R5066 VGND.n1445 VGND.n1444 0.0260814
R5067 VGND.n797 VGND.n778 0.025963
R5068 VGND.n1157 VGND.n835 0.0258263
R5069 VGND.n1434 VGND.n1433 0.0255698
R5070 VGND.n805 VGND.n804 0.0254537
R5071 VGND.n1462 VGND.n1461 0.0245465
R5072 VGND.n768 VGND.n767 0.0244352
R5073 VGND.n1468 VGND.n761 0.0240349
R5074 VGND.n763 VGND.n762 0.0239259
R5075 VGND.n1443 VGND.n1442 0.0235233
R5076 VGND.t25 VGND.n430 0.0234448
R5077 VGND.n780 VGND.n779 0.0234167
R5078 VGND.n1436 VGND.n1435 0.0230116
R5079 VGND.n785 VGND.n784 0.0229074
R5080 VGND.n2009 VGND.n2008 0.0219416
R5081 VGND.n1969 VGND.n1967 0.0219416
R5082 VGND.n1977 VGND.n1967 0.0219416
R5083 VGND.n1978 VGND.n1977 0.0219416
R5084 VGND.n1978 VGND.n1966 0.0219416
R5085 VGND.n1966 VGND.n1961 0.0219416
R5086 VGND.n1987 VGND.n1961 0.0219416
R5087 VGND.n1988 VGND.n1987 0.0219416
R5088 VGND.n1989 VGND.n1988 0.0219416
R5089 VGND.n1933 VGND.n55 0.0605208
R5090 VGND.n60 VGND.n532 0.0218333
R5091 VGND.n546 VGND.t34 0.0218333
R5092 VGND.n557 VGND.n556 0.0218333
R5093 VGND.n558 VGND.n557 0.0218333
R5094 VGND.n558 VGND.n465 0.0218333
R5095 VGND.n565 VGND.n465 0.0218333
R5096 VGND.n566 VGND.n565 0.0218333
R5097 VGND.n567 VGND.n566 0.0218333
R5098 VGND.n567 VGND.n459 0.0218333
R5099 VGND.n575 VGND.n459 0.0218333
R5100 VGND.n63 VGND.n585 0.0218333
R5101 VGND.n599 VGND.t38 0.0218333
R5102 VGND.n1464 VGND.n1463 0.0214767
R5103 VGND.n1194 VGND.n1193 0.0213704
R5104 VGND.n1160 VGND.n837 0.0212426
R5105 VGND.n67 VGND.n1363 0.021125
R5106 VGND.n1467 VGND.n1466 0.0209651
R5107 VGND.n1441 VGND.n1440 0.0209651
R5108 VGND.n795 VGND.n781 0.0208704
R5109 VGND.n814 VGND.n764 0.0208704
R5110 VGND.n1452 VGND.n1451 0.0206794
R5111 VGND.n1438 VGND.n1437 0.0204535
R5112 VGND.n807 VGND.n806 0.0203611
R5113 VGND.n1183 VGND.n1171 0.0200556
R5114 VGND.n1363 VGND.n831 0.0199792
R5115 VGND.n1424 VGND.n1423 0.0198519
R5116 VGND.n1218 VGND.n1210 0.0198023
R5117 VGND.n1155 VGND.n1149 0.0197149
R5118 VGND.n891 VGND.n883 0.0194244
R5119 VGND.n1428 VGND.n1427 0.0194063
R5120 VGND.n892 VGND.n883 0.0194032
R5121 VGND.n1453 VGND.n1452 0.0191445
R5122 VGND.n1216 VGND.n1211 0.0190349
R5123 VGND.t25 VGND.n224 0.0530141
R5124 VGND.n1219 VGND.n1212 0.0185233
R5125 VGND.n1555 VGND.n1552 0.0184123
R5126 VGND.n1466 VGND.n1465 0.018407
R5127 VGND.n1439 VGND.n1438 0.018407
R5128 VGND.n1884 VGND.n1883 0.01839
R5129 VGND.n783 VGND.n782 0.0183241
R5130 VGND.n765 VGND.n764 0.0183241
R5131 VGND.n1465 VGND.n1464 0.0178953
R5132 VGND.n1440 VGND.n1439 0.0178953
R5133 VGND.n782 VGND.n781 0.0178148
R5134 VGND.n766 VGND.n765 0.0178148
R5135 VGND.n1215 VGND.n1213 0.0177558
R5136 VGND.n889 VGND.n887 0.0173389
R5137 VGND.n1166 VGND.n1165 0.0173056
R5138 VGND.n2067 VGND.n380 0.0170973
R5139 VGND.n2048 VGND.n380 0.0170973
R5140 VGND.n2048 VGND.n2046 0.0170973
R5141 VGND.n2052 VGND.n2046 0.0170973
R5142 VGND.n2053 VGND.n2052 0.0170973
R5143 VGND.n2054 VGND.n2053 0.0170973
R5144 VGND.n2054 VGND.n2040 0.0170973
R5145 VGND.n2058 VGND.n2040 0.0170973
R5146 VGND.n2059 VGND.n2058 0.0170973
R5147 VGND.n2060 VGND.n2059 0.0170973
R5148 VGND.n2060 VGND.n393 0.0170973
R5149 VGND.n2064 VGND.n393 0.0170973
R5150 VGND.n2047 VGND.n381 0.0170973
R5151 VGND.n2045 VGND.n2044 0.0170973
R5152 VGND.n2043 VGND.n2042 0.0170973
R5153 VGND.n2039 VGND.n2038 0.0170973
R5154 VGND.n2037 VGND.n2036 0.0170973
R5155 VGND.n2065 VGND.n392 0.0170973
R5156 VGND.n522 VGND.n491 0.0170973
R5157 VGND.n516 VGND.n492 0.0170973
R5158 VGND.n514 VGND.n513 0.0170973
R5159 VGND.n507 VGND.n506 0.0170973
R5160 VGND.n504 VGND.n503 0.0170973
R5161 VGND.n498 VGND.n490 0.0170973
R5162 VGND.n521 VGND.n494 0.0170973
R5163 VGND.n521 VGND.n493 0.0170973
R5164 VGND.n517 VGND.n493 0.0170973
R5165 VGND.n517 VGND.n515 0.0170973
R5166 VGND.n515 VGND.n512 0.0170973
R5167 VGND.n512 VGND.n496 0.0170973
R5168 VGND.n508 VGND.n496 0.0170973
R5169 VGND.n508 VGND.n505 0.0170973
R5170 VGND.n505 VGND.n502 0.0170973
R5171 VGND.n502 VGND.n499 0.0170973
R5172 VGND.n499 VGND.n489 0.0170973
R5173 VGND.n524 VGND.n489 0.0170973
R5174 VGND.n890 VGND.n889 0.017069
R5175 VGND.n520 VGND.n162 0.0170647
R5176 VGND.n520 VGND.n519 0.0170647
R5177 VGND.n519 VGND.n518 0.0170647
R5178 VGND.n518 VGND.n495 0.0170647
R5179 VGND.n511 VGND.n495 0.0170647
R5180 VGND.n511 VGND.n510 0.0170647
R5181 VGND.n510 VGND.n509 0.0170647
R5182 VGND.n509 VGND.n497 0.0170647
R5183 VGND.n501 VGND.n497 0.0170647
R5184 VGND.n501 VGND.n500 0.0170647
R5185 VGND.n500 VGND.n488 0.0170647
R5186 VGND.n525 VGND.n488 0.0170647
R5187 VGND.n528 VGND.n527 0.0170647
R5188 VGND.n529 VGND.n528 0.0170647
R5189 VGND.n529 VGND.n482 0.0170647
R5190 VGND.n535 VGND.n482 0.0170647
R5191 VGND.n536 VGND.n535 0.0170647
R5192 VGND.n537 VGND.n536 0.0170647
R5193 VGND.n537 VGND.n479 0.0170647
R5194 VGND.n541 VGND.n479 0.0170647
R5195 VGND.n542 VGND.n541 0.0170647
R5196 VGND.n543 VGND.n542 0.0170647
R5197 VGND.n543 VGND.n474 0.0170647
R5198 VGND.n549 VGND.n474 0.0170647
R5199 VGND.n552 VGND.n551 0.0170647
R5200 VGND.n553 VGND.n552 0.0170647
R5201 VGND.n553 VGND.n468 0.0170647
R5202 VGND.n561 VGND.n468 0.0170647
R5203 VGND.n562 VGND.n561 0.0170647
R5204 VGND.n563 VGND.n562 0.0170647
R5205 VGND.n563 VGND.n462 0.0170647
R5206 VGND.n570 VGND.n462 0.0170647
R5207 VGND.n571 VGND.n570 0.0170647
R5208 VGND.n572 VGND.n571 0.0170647
R5209 VGND.n572 VGND.n456 0.0170647
R5210 VGND.n578 VGND.n456 0.0170647
R5211 VGND.n581 VGND.n580 0.0170647
R5212 VGND.n582 VGND.n581 0.0170647
R5213 VGND.n582 VGND.n450 0.0170647
R5214 VGND.n588 VGND.n450 0.0170647
R5215 VGND.n589 VGND.n588 0.0170647
R5216 VGND.n590 VGND.n589 0.0170647
R5217 VGND.n590 VGND.n447 0.0170647
R5218 VGND.n594 VGND.n447 0.0170647
R5219 VGND.n595 VGND.n594 0.0170647
R5220 VGND.n596 VGND.n595 0.0170647
R5221 VGND.n596 VGND.n442 0.0170647
R5222 VGND.n602 VGND.n442 0.0170647
R5223 VGND.n1913 VGND.n1912 0.0170647
R5224 VGND.n1914 VGND.n1913 0.0170647
R5225 VGND.n1914 VGND.n437 0.0170647
R5226 VGND.n1918 VGND.n437 0.0170647
R5227 VGND.n1919 VGND.n1918 0.0170647
R5228 VGND.n1902 VGND.n436 0.0170647
R5229 VGND.n1902 VGND.n1901 0.0170647
R5230 VGND.n1901 VGND.n1900 0.0170647
R5231 VGND.n1911 VGND.n441 0.0170647
R5232 VGND.n1915 VGND.n441 0.0170647
R5233 VGND.n1916 VGND.n1915 0.0170647
R5234 VGND.n1917 VGND.n1916 0.0170647
R5235 VGND.n1917 VGND.n435 0.0170647
R5236 VGND.n1903 VGND.n434 0.0170647
R5237 VGND.n1903 VGND.n1892 0.0170647
R5238 VGND.n1899 VGND.n1892 0.0170647
R5239 VGND.n1899 VGND.n1894 0.0170647
R5240 VGND.n603 VGND.n440 0.0170647
R5241 VGND.n440 VGND.n439 0.0170647
R5242 VGND.n439 VGND.n438 0.0170647
R5243 VGND.n438 VGND.n433 0.0170647
R5244 VGND.n1904 VGND.n432 0.0170647
R5245 VGND.n1904 VGND.n1891 0.0170647
R5246 VGND.n1898 VGND.n1891 0.0170647
R5247 VGND.n1898 VGND.n1895 0.0170647
R5248 VGND.n1923 VGND.n425 0.0170647
R5249 VGND.n627 VGND.n425 0.0170647
R5250 VGND.n627 VGND.n624 0.0170647
R5251 VGND.n631 VGND.n624 0.0170647
R5252 VGND.n631 VGND.n606 0.0170647
R5253 VGND.n637 VGND.n606 0.0170647
R5254 VGND.n637 VGND.n605 0.0170647
R5255 VGND.n618 VGND.n605 0.0170647
R5256 VGND.n618 VGND.n611 0.0170647
R5257 VGND.n612 VGND.n611 0.0170647
R5258 VGND.n1924 VGND.n424 0.0170647
R5259 VGND.n626 VGND.n424 0.0170647
R5260 VGND.n626 VGND.n623 0.0170647
R5261 VGND.n632 VGND.n623 0.0170647
R5262 VGND.n632 VGND.n608 0.0170647
R5263 VGND.n636 VGND.n608 0.0170647
R5264 VGND.n636 VGND.n607 0.0170647
R5265 VGND.n619 VGND.n607 0.0170647
R5266 VGND.n619 VGND.n610 0.0170647
R5267 VGND.n613 VGND.n610 0.0170647
R5268 VGND.n163 VGND.n379 0.0170647
R5269 VGND.n2049 VGND.n379 0.0170647
R5270 VGND.n2050 VGND.n2049 0.0170647
R5271 VGND.n2051 VGND.n2050 0.0170647
R5272 VGND.n2051 VGND.n2041 0.0170647
R5273 VGND.n2055 VGND.n2041 0.0170647
R5274 VGND.n2056 VGND.n2055 0.0170647
R5275 VGND.n2057 VGND.n2056 0.0170647
R5276 VGND.n2057 VGND.n2035 0.0170647
R5277 VGND.n2061 VGND.n2035 0.0170647
R5278 VGND.n2062 VGND.n2061 0.0170647
R5279 VGND.n2063 VGND.n2062 0.0170647
R5280 VGND.n2034 VGND.n394 0.0170647
R5281 VGND.n2012 VGND.n394 0.0170647
R5282 VGND.n2013 VGND.n2012 0.0170647
R5283 VGND.n2014 VGND.n2013 0.0170647
R5284 VGND.n2014 VGND.n2003 0.0170647
R5285 VGND.n2020 VGND.n2003 0.0170647
R5286 VGND.n2021 VGND.n2020 0.0170647
R5287 VGND.n2022 VGND.n2021 0.0170647
R5288 VGND.n2022 VGND.n2000 0.0170647
R5289 VGND.n2028 VGND.n2000 0.0170647
R5290 VGND.n2029 VGND.n2028 0.0170647
R5291 VGND.n2030 VGND.n2029 0.0170647
R5292 VGND.n1999 VGND.n401 0.0170647
R5293 VGND.n1972 VGND.n401 0.0170647
R5294 VGND.n1973 VGND.n1972 0.0170647
R5295 VGND.n1974 VGND.n1973 0.0170647
R5296 VGND.n1974 VGND.n1963 0.0170647
R5297 VGND.n1982 VGND.n1963 0.0170647
R5298 VGND.n1983 VGND.n1982 0.0170647
R5299 VGND.n1984 VGND.n1983 0.0170647
R5300 VGND.n1984 VGND.n1959 0.0170647
R5301 VGND.n1992 VGND.n1959 0.0170647
R5302 VGND.n1993 VGND.n1992 0.0170647
R5303 VGND.n1994 VGND.n1993 0.0170647
R5304 VGND.n1958 VGND.n416 0.0170647
R5305 VGND.n1936 VGND.n416 0.0170647
R5306 VGND.n1937 VGND.n1936 0.0170647
R5307 VGND.n1938 VGND.n1937 0.0170647
R5308 VGND.n1938 VGND.n1930 0.0170647
R5309 VGND.n1944 VGND.n1930 0.0170647
R5310 VGND.n1945 VGND.n1944 0.0170647
R5311 VGND.n1946 VGND.n1945 0.0170647
R5312 VGND.n1946 VGND.n1926 0.0170647
R5313 VGND.n1952 VGND.n1926 0.0170647
R5314 VGND.n1953 VGND.n1952 0.0170647
R5315 VGND.n1954 VGND.n1953 0.0170647
R5316 VGND.n1925 VGND.n423 0.0170647
R5317 VGND.n625 VGND.n423 0.0170647
R5318 VGND.n625 VGND.n622 0.0170647
R5319 VGND.n633 VGND.n622 0.0170647
R5320 VGND.n634 VGND.n633 0.0170647
R5321 VGND.n635 VGND.n634 0.0170647
R5322 VGND.n635 VGND.n621 0.0170647
R5323 VGND.n621 VGND.n620 0.0170647
R5324 VGND.n620 VGND.n609 0.0170647
R5325 VGND.n2033 VGND.n395 0.0170647
R5326 VGND.n2011 VGND.n395 0.0170647
R5327 VGND.n2011 VGND.n2006 0.0170647
R5328 VGND.n2015 VGND.n2006 0.0170647
R5329 VGND.n2015 VGND.n2004 0.0170647
R5330 VGND.n2019 VGND.n2004 0.0170647
R5331 VGND.n2019 VGND.n2002 0.0170647
R5332 VGND.n2023 VGND.n2002 0.0170647
R5333 VGND.n2023 VGND.n2001 0.0170647
R5334 VGND.n2027 VGND.n2001 0.0170647
R5335 VGND.n2027 VGND.n400 0.0170647
R5336 VGND.n2031 VGND.n400 0.0170647
R5337 VGND.n2010 VGND.n2007 0.0170647
R5338 VGND.n2017 VGND.n2016 0.0170647
R5339 VGND.n2018 VGND.n2005 0.0170647
R5340 VGND.n2025 VGND.n2024 0.0170647
R5341 VGND.n2026 VGND.n66 0.00513547
R5342 VGND.n531 VGND.n486 0.0170647
R5343 VGND.n531 VGND.n484 0.0170647
R5344 VGND.n533 VGND.n484 0.0170647
R5345 VGND.n61 VGND.n157 0.00925955
R5346 VGND.n261 VGND.n157 0.0170647
R5347 VGND.n261 VGND.n59 0.00335487
R5348 VGND.n539 VGND.n252 0.0170647
R5349 VGND.n218 VGND.n477 0.00925955
R5350 VGND.n545 VGND.n477 0.0170647
R5351 VGND.n545 VGND.n476 0.0170647
R5352 VGND.n526 VGND.n487 0.0170647
R5353 VGND.n530 VGND.n487 0.0170647
R5354 VGND.n530 VGND.n483 0.0170647
R5355 VGND.n534 VGND.n483 0.0170647
R5356 VGND.n534 VGND.n481 0.0170647
R5357 VGND.n538 VGND.n481 0.0170647
R5358 VGND.n538 VGND.n480 0.0170647
R5359 VGND.n540 VGND.n480 0.0170647
R5360 VGND.n540 VGND.n478 0.0170647
R5361 VGND.n544 VGND.n478 0.0170647
R5362 VGND.n544 VGND.n475 0.0170647
R5363 VGND.n548 VGND.n475 0.0170647
R5364 VGND.n1998 VGND.n402 0.0170647
R5365 VGND.n1971 VGND.n402 0.0170647
R5366 VGND.n1971 VGND.n1968 0.0170647
R5367 VGND.n1975 VGND.n1968 0.0170647
R5368 VGND.n1975 VGND.n1964 0.0170647
R5369 VGND.n1981 VGND.n1964 0.0170647
R5370 VGND.n1981 VGND.n1962 0.0170647
R5371 VGND.n1985 VGND.n1962 0.0170647
R5372 VGND.n1985 VGND.n1960 0.0170647
R5373 VGND.n1991 VGND.n1960 0.0170647
R5374 VGND.n1991 VGND.n415 0.0170647
R5375 VGND.n1995 VGND.n415 0.0170647
R5376 VGND.n1970 VGND.n406 0.0170647
R5377 VGND.n1976 VGND.n406 0.0170647
R5378 VGND.n1980 VGND.n1979 0.0170647
R5379 VGND.n1980 VGND.n1965 0.0170647
R5380 VGND.n1986 VGND.n404 0.0170647
R5381 VGND.n1990 VGND.n404 0.0170647
R5382 VGND.n555 VGND.n472 0.0170647
R5383 VGND.n555 VGND.n470 0.0170647
R5384 VGND.n559 VGND.n470 0.0170647
R5385 VGND.n559 VGND.n466 0.0170647
R5386 VGND.n410 VGND.n466 0.0170647
R5387 VGND.n410 VGND.n464 0.0170647
R5388 VGND.n568 VGND.n464 0.0170647
R5389 VGND.n568 VGND.n460 0.0170647
R5390 VGND.n574 VGND.n460 0.0170647
R5391 VGND.n574 VGND.n458 0.0170647
R5392 VGND.n550 VGND.n473 0.0170647
R5393 VGND.n554 VGND.n473 0.0170647
R5394 VGND.n554 VGND.n469 0.0170647
R5395 VGND.n560 VGND.n469 0.0170647
R5396 VGND.n560 VGND.n467 0.0170647
R5397 VGND.n564 VGND.n467 0.0170647
R5398 VGND.n564 VGND.n463 0.0170647
R5399 VGND.n569 VGND.n463 0.0170647
R5400 VGND.n569 VGND.n461 0.0170647
R5401 VGND.n573 VGND.n461 0.0170647
R5402 VGND.n573 VGND.n457 0.0170647
R5403 VGND.n577 VGND.n457 0.0170647
R5404 VGND.n1957 VGND.n417 0.0170647
R5405 VGND.n1935 VGND.n417 0.0170647
R5406 VGND.n1935 VGND.n1932 0.0170647
R5407 VGND.n1939 VGND.n1932 0.0170647
R5408 VGND.n1939 VGND.n1931 0.0170647
R5409 VGND.n1943 VGND.n1931 0.0170647
R5410 VGND.n1943 VGND.n1929 0.0170647
R5411 VGND.n1947 VGND.n1929 0.0170647
R5412 VGND.n1947 VGND.n1927 0.0170647
R5413 VGND.n1951 VGND.n1927 0.0170647
R5414 VGND.n1951 VGND.n422 0.0170647
R5415 VGND.n1955 VGND.n422 0.0170647
R5416 VGND.n1934 VGND.n419 0.0170647
R5417 VGND.n1940 VGND.n419 0.0170647
R5418 VGND.n1942 VGND.n1941 0.0170647
R5419 VGND.n1948 VGND.n1928 0.0170647
R5420 VGND.n1950 VGND.n1949 0.0170647
R5421 VGND.n584 VGND.n454 0.0170647
R5422 VGND.n584 VGND.n452 0.0170647
R5423 VGND.n586 VGND.n452 0.0170647
R5424 VGND.n64 VGND.n156 0.00925955
R5425 VGND.n260 VGND.n156 0.0170647
R5426 VGND.n260 VGND.n62 0.00335487
R5427 VGND.n592 VGND.n253 0.0170647
R5428 VGND.n219 VGND.n445 0.00925955
R5429 VGND.n598 VGND.n445 0.0170647
R5430 VGND.n598 VGND.n444 0.0170647
R5431 VGND.n579 VGND.n455 0.0170647
R5432 VGND.n583 VGND.n455 0.0170647
R5433 VGND.n583 VGND.n451 0.0170647
R5434 VGND.n587 VGND.n451 0.0170647
R5435 VGND.n587 VGND.n449 0.0170647
R5436 VGND.n591 VGND.n449 0.0170647
R5437 VGND.n591 VGND.n448 0.0170647
R5438 VGND.n593 VGND.n448 0.0170647
R5439 VGND.n593 VGND.n446 0.0170647
R5440 VGND.n597 VGND.n446 0.0170647
R5441 VGND.n597 VGND.n443 0.0170647
R5442 VGND.n601 VGND.n443 0.0170647
R5443 VGND.n1221 VGND.n1220 0.0168721
R5444 VGND.n1437 VGND.n1436 0.0158488
R5445 VGND.n787 VGND.n784 0.0157778
R5446 VGND.n1468 VGND.n1467 0.0153372
R5447 VGND.n1442 VGND.n1441 0.0153372
R5448 VGND.n1463 VGND.n1462 0.0148256
R5449 VGND.n816 VGND.n767 0.0147593
R5450 VGND.n1353 VGND.n1352 0.01425
R5451 VGND.n788 VGND.n787 0.01425
R5452 VGND.n1174 VGND.n1173 0.0138333
R5453 VGND.n817 VGND.n816 0.0137407
R5454 VGND.n1435 VGND.n1434 0.0132907
R5455 VGND.n786 VGND.n785 0.0132315
R5456 VGND.n1163 VGND.n14 0.0696487
R5457 VGND.n1179 VGND.n1178 0.0128164
R5458 VGND.n1189 VGND.n1179 0.0128164
R5459 VGND.n1444 VGND.n1443 0.0127791
R5460 VGND.n779 VGND.n778 0.0127222
R5461 VGND.n1218 VGND.n1209 0.0123407
R5462 VGND.n1469 VGND.n761 0.0122674
R5463 VGND.n1426 VGND.n762 0.012213
R5464 VGND.n1356 VGND.n1355 0.0119583
R5465 VGND.n32 VGND.n1155 0.0119583
R5466 VGND.n1922 VGND.n426 0.0119472
R5467 VGND.n628 VGND.n426 0.0119472
R5468 VGND.n629 VGND.n628 0.0119472
R5469 VGND.n630 VGND.n629 0.0119472
R5470 VGND.n630 VGND.n604 0.0119472
R5471 VGND.n428 VGND.n604 0.0119472
R5472 VGND.n617 VGND.n427 0.0119472
R5473 VGND.n617 VGND.n616 0.0119472
R5474 VGND.n1461 VGND.n1460 0.0117558
R5475 VGND.n769 VGND.n768 0.0117037
R5476 VGND.n1223 VGND.t49 0.0115743
R5477 VGND.n1358 VGND.n1357 0.0113854
R5478 VGND.n1217 VGND.n1209 0.0113336
R5479 VGND.n1174 VGND.n1172 0.0110926
R5480 VGND.n1433 VGND.n1432 0.0107326
R5481 VGND.n1425 VGND.n1424 0.0106852
R5482 VGND.t25 VGND.n427 0.0106355
R5483 VGND.n1158 VGND.n837 0.0104306
R5484 VGND.n1446 VGND.n1445 0.0102209
R5485 VGND.n1090 VGND.n880 0.00978471
R5486 VGND.t59 VGND.n962 0.00940274
R5487 VGND.n2032 VGND.n396 0.00928904
R5488 VGND.n2031 VGND.n65 2.25851
R5489 VGND.n1997 VGND.n403 0.00928904
R5490 VGND.n1996 VGND.n413 0.00928904
R5491 VGND.n1956 VGND.n418 0.00928904
R5492 VGND.n159 VGND.n158 0.0110013
R5493 VGND.n2010 VGND.n399 0.00927474
R5494 VGND.n2016 VGND.n57 0.00450749
R5495 VGND.n2026 VGND.n161 0.0150317
R5496 VGND.n399 VGND.n398 0.00927474
R5497 VGND.n2007 VGND.n57 0.0150317
R5498 VGND.n2018 VGND.n220 0.0104363
R5499 VGND.n2024 VGND.n238 0.010059
R5500 VGND.n2025 VGND.n161 0.00450749
R5501 VGND.n1970 VGND.n408 0.00927474
R5502 VGND.n1979 VGND.n411 0.00927474
R5503 VGND.n1986 VGND.n405 0.00927474
R5504 VGND.n414 VGND.n412 0.00927474
R5505 VGND.n408 VGND.n407 0.00927474
R5506 VGND.n1976 VGND.n411 0.00927474
R5507 VGND.n1965 VGND.n405 0.00927474
R5508 VGND.n1990 VGND.n412 0.00927474
R5509 VGND.n1934 VGND.n421 0.00927474
R5510 VGND.n158 VGND.n160 0.0150317
R5511 VGND.n421 VGND.n420 0.00927474
R5512 VGND.n1941 VGND.n56 0.0104363
R5513 VGND.n1942 VGND.n255 0.0104363
R5514 VGND.n1948 VGND.n221 0.0104363
R5515 VGND.n1950 VGND.n160 0.00450749
R5516 VGND.n2045 VGND.n382 0.00925297
R5517 VGND.n2043 VGND.n383 0.00925297
R5518 VGND.n2039 VGND.n384 0.00925297
R5519 VGND.n2037 VGND.n385 0.00925297
R5520 VGND.n392 VGND.n386 0.00925297
R5521 VGND.n2066 VGND.n381 0.00925297
R5522 VGND.n2047 VGND.n382 0.00925297
R5523 VGND.n2044 VGND.n383 0.00925297
R5524 VGND.n2042 VGND.n384 0.00925297
R5525 VGND.n2038 VGND.n385 0.00925297
R5526 VGND.n2036 VGND.n386 0.00925297
R5527 VGND.n391 VGND.n522 0.00925297
R5528 VGND.n514 VGND.n390 0.00925297
R5529 VGND.n506 VGND.n389 0.00925297
R5530 VGND.n504 VGND.n388 0.00925297
R5531 VGND.n498 VGND.n387 0.00925297
R5532 VGND.n523 VGND.n490 0.00925297
R5533 VGND.n391 VGND.n492 0.00925297
R5534 VGND.n516 VGND.n390 0.00925297
R5535 VGND.n513 VGND.n389 0.00925297
R5536 VGND.n507 VGND.n388 0.00925297
R5537 VGND.n503 VGND.n387 0.00925297
R5538 VGND.n1894 VGND.n1893 0.00923687
R5539 VGND.n615 VGND.n612 0.00923112
R5540 VGND.n486 VGND.n485 0.00923037
R5541 VGND.n547 VGND.n476 0.00923037
R5542 VGND.n472 VGND.n471 0.00923037
R5543 VGND.n576 VGND.n458 0.00923037
R5544 VGND.n454 VGND.n453 0.00923037
R5545 VGND.n600 VGND.n444 0.00923037
R5546 VGND.n398 VGND.n396 0.00923022
R5547 VGND.n65 VGND.n397 0.0110013
R5548 VGND.n407 VGND.n403 0.00923022
R5549 VGND.n414 VGND.n413 0.00923022
R5550 VGND.n420 VGND.n418 0.00923022
R5551 VGND.n1910 VGND.n603 0.00922413
R5552 VGND.n1896 VGND.n1895 0.00922413
R5553 VGND.n614 VGND.n613 0.00922182
R5554 VGND.n796 VGND.n795 0.00915741
R5555 VGND.n1194 VGND.n1172 0.00914814
R5556 VGND.n1920 VGND.n1919 0.00878235
R5557 VGND.n1920 VGND.n436 0.00878235
R5558 VGND.n1921 VGND.n435 0.00878235
R5559 VGND.n1921 VGND.n434 0.00878235
R5560 VGND.n431 VGND.n433 0.00878235
R5561 VGND.n431 VGND.n432 0.00878235
R5562 VGND.n1459 VGND.n1458 0.00868605
R5563 VGND.n806 VGND.n770 0.00864815
R5564 VGND.n1251 VGND.n871 0.00829167
R5565 VGND.n817 VGND.n766 0.00813889
R5566 VGND.n815 VGND.n763 0.00813889
R5567 VGND.n1223 VGND.n1138 0.00796124
R5568 VGND.n1173 VGND.n1171 0.00772222
R5569 VGND.n1448 VGND.n1447 0.00766279
R5570 VGND.n776 VGND.n775 0.00762963
R5571 VGND.n805 VGND.n772 0.00762963
R5572 VGND.n807 VGND.n769 0.00762963
R5573 VGND.n815 VGND.n814 0.00762963
R5574 VGND.n798 VGND.n777 0.00712037
R5575 VGND.n40 VGND.n38 0.00711928
R5576 VGND.n1244 VGND.n876 0.00691667
R5577 VGND.n1249 VGND.n1248 0.00691667
R5578 VGND.n1431 VGND.n21 0.00670882
R5579 VGND.n788 VGND.n783 0.00661111
R5580 VGND.n796 VGND.n780 0.00661111
R5581 VGND.n1457 VGND.n1456 0.00612791
R5582 VGND.n1423 VGND.n786 0.00610185
R5583 VGND.n772 VGND.n771 0.00610185
R5584 VGND.n1183 VGND.n1182 0.0057963
R5585 VGND.n1182 VGND.n1170 0.0057963
R5586 VGND.n1242 VGND.n1241 0.00554167
R5587 VGND.n1450 VGND.n1449 0.00510465
R5588 VGND.n1360 VGND.n1359 0.00508333
R5589 VGND.n1412 VGND.n774 0.00508333
R5590 VGND.n888 VGND.n885 0.00491213
R5591 VGND.n565 VGND.t36 0.00436447
R5592 VGND.t21 VGND.n409 0.0041367
R5593 VGND.n1221 VGND.n1214 0.0040814
R5594 VGND.n893 VGND.n887 0.00399163
R5595 VGND.n886 VGND.n873 0.00399163
R5596 VGND.n1220 VGND.n1213 0.00394186
R5597 VGND.n1455 VGND.n1454 0.00356977
R5598 VGND.n798 VGND.n797 0.00355556
R5599 VGND.n804 VGND.n9 0.0213528
R5600 VGND.n1905 VGND.t25 0.00346933
R5601 VGND.n1215 VGND.n1212 0.00343023
R5602 VGND.n1169 VGND.n1168 0.00324074
R5603 VGND.n891 VGND.n877 0.00280126
R5604 VGND.n894 VGND.n873 0.00280126
R5605 VGND.n1219 VGND.n1211 0.00266279
R5606 VGND.n2071 VGND.n376 0.00264144
R5607 VGND.n1793 VGND.n376 0.00264144
R5608 VGND.n1794 VGND.n1793 0.00264144
R5609 VGND.n1795 VGND.n1794 0.00264144
R5610 VGND.n1795 VGND.n1751 0.00264144
R5611 VGND.n1799 VGND.n1751 0.00264144
R5612 VGND.n1800 VGND.n1799 0.00264144
R5613 VGND.n1801 VGND.n1800 0.00264144
R5614 VGND.n1801 VGND.n1746 0.00264144
R5615 VGND.n1805 VGND.n1746 0.00264144
R5616 VGND.n1806 VGND.n1805 0.00264144
R5617 VGND.n1807 VGND.n1806 0.00264144
R5618 VGND.n1807 VGND.n1741 0.00264144
R5619 VGND.n1811 VGND.n1741 0.00264144
R5620 VGND.n1812 VGND.n1811 0.00264144
R5621 VGND.n1813 VGND.n1812 0.00264144
R5622 VGND.n1813 VGND.n1736 0.00264144
R5623 VGND.n1817 VGND.n1736 0.00264144
R5624 VGND.n1818 VGND.n1817 0.00264144
R5625 VGND.n1819 VGND.n1818 0.00264144
R5626 VGND.n1819 VGND.n1731 0.00264144
R5627 VGND.n1823 VGND.n1731 0.00264144
R5628 VGND.n1824 VGND.n1823 0.00264144
R5629 VGND.n1825 VGND.n1824 0.00264144
R5630 VGND.n1825 VGND.n1726 0.00264144
R5631 VGND.n1829 VGND.n1726 0.00264144
R5632 VGND.n1830 VGND.n1829 0.00264144
R5633 VGND.n1831 VGND.n1830 0.00264144
R5634 VGND.n1831 VGND.n1721 0.00264144
R5635 VGND.n1835 VGND.n1721 0.00264144
R5636 VGND.n1836 VGND.n1835 0.00264144
R5637 VGND.n1837 VGND.n1836 0.00264144
R5638 VGND.n1837 VGND.n1716 0.00264144
R5639 VGND.n1841 VGND.n1716 0.00264144
R5640 VGND.n1842 VGND.n1841 0.00264144
R5641 VGND.n1843 VGND.n1842 0.00264144
R5642 VGND.n1843 VGND.n1711 0.00264144
R5643 VGND.n1847 VGND.n1711 0.00264144
R5644 VGND.n1848 VGND.n1847 0.00264144
R5645 VGND.n1849 VGND.n1848 0.00264144
R5646 VGND.n1849 VGND.n1706 0.00264144
R5647 VGND.n1853 VGND.n1706 0.00264144
R5648 VGND.n1854 VGND.n1853 0.00264144
R5649 VGND.n1855 VGND.n1854 0.00264144
R5650 VGND.n1855 VGND.n1701 0.00264144
R5651 VGND.n1859 VGND.n1701 0.00264144
R5652 VGND.n1860 VGND.n1859 0.00264144
R5653 VGND.n1861 VGND.n1860 0.00264144
R5654 VGND.n1861 VGND.n1696 0.00264144
R5655 VGND.n1865 VGND.n1696 0.00264144
R5656 VGND.n1866 VGND.n1865 0.00264144
R5657 VGND.n1867 VGND.n1866 0.00264144
R5658 VGND.n1867 VGND.n1691 0.00264144
R5659 VGND.n1871 VGND.n1691 0.00264144
R5660 VGND.n1872 VGND.n1871 0.00264144
R5661 VGND.n1873 VGND.n1872 0.00264144
R5662 VGND.n1873 VGND.n1686 0.00264144
R5663 VGND.n1877 VGND.n1686 0.00264144
R5664 VGND.n1878 VGND.n1877 0.00264144
R5665 VGND.n1879 VGND.n1878 0.00264144
R5666 VGND.n1879 VGND.n1681 0.00264144
R5667 VGND.n1883 VGND.n1681 0.00264144
R5668 VGND.n1884 VGND.n1680 0.00264144
R5669 VGND.n1680 VGND.n1679 0.00264144
R5670 VGND.n1679 VGND.n647 0.00264144
R5671 VGND.n1675 VGND.n647 0.00264144
R5672 VGND.n1675 VGND.n1674 0.00264144
R5673 VGND.n1674 VGND.n1673 0.00264144
R5674 VGND.n1673 VGND.n650 0.00264144
R5675 VGND.n1668 VGND.n650 0.00264144
R5676 VGND.n1668 VGND.n1667 0.00264144
R5677 VGND.n1667 VGND.n1666 0.00264144
R5678 VGND.n1666 VGND.n652 0.00264144
R5679 VGND.n1655 VGND.n652 0.00264144
R5680 VGND.n1656 VGND.n1655 0.00264144
R5681 VGND.n1656 VGND.n1654 0.00264144
R5682 VGND.n1654 VGND.n1653 0.00264144
R5683 VGND.n1653 VGND.n658 0.00264144
R5684 VGND.n1644 VGND.n658 0.00264144
R5685 VGND.n1645 VGND.n1644 0.00264144
R5686 VGND.n1645 VGND.n1643 0.00264144
R5687 VGND.n1643 VGND.n1642 0.00264144
R5688 VGND.n1642 VGND.n663 0.00264144
R5689 VGND.n1636 VGND.n663 0.00264144
R5690 VGND.n1636 VGND.n1635 0.00264144
R5691 VGND.n1635 VGND.n1634 0.00264144
R5692 VGND.n1634 VGND.n668 0.00264144
R5693 VGND.n1628 VGND.n668 0.00264144
R5694 VGND.n1628 VGND.n1627 0.00264144
R5695 VGND.n1627 VGND.n1626 0.00264144
R5696 VGND.n1626 VGND.n673 0.00264144
R5697 VGND.n1620 VGND.n673 0.00264144
R5698 VGND.n1620 VGND.n1619 0.00264144
R5699 VGND.n1619 VGND.n1618 0.00264144
R5700 VGND.n1618 VGND.n678 0.00264144
R5701 VGND.n1612 VGND.n678 0.00264144
R5702 VGND.n1612 VGND.n1611 0.00264144
R5703 VGND.n1611 VGND.n1610 0.00264144
R5704 VGND.n1610 VGND.n683 0.00264144
R5705 VGND.n1604 VGND.n683 0.00264144
R5706 VGND.n1604 VGND.n1603 0.00264144
R5707 VGND.n1603 VGND.n1602 0.00264144
R5708 VGND.n1602 VGND.n689 0.00264144
R5709 VGND.n1596 VGND.n689 0.00264144
R5710 VGND.n1596 VGND.n1595 0.00264144
R5711 VGND.n1595 VGND.n1594 0.00264144
R5712 VGND.n1594 VGND.n695 0.00264144
R5713 VGND.n1587 VGND.n695 0.00264144
R5714 VGND.n1587 VGND.n1586 0.00264144
R5715 VGND.n1586 VGND.n1585 0.00264144
R5716 VGND.n1585 VGND.n700 0.00264144
R5717 VGND.n1577 VGND.n700 0.00264144
R5718 VGND.n1578 VGND.n1577 0.00264144
R5719 VGND.n1578 VGND.n1576 0.00264144
R5720 VGND.n1576 VGND.n1575 0.00264144
R5721 VGND.n1575 VGND.n706 0.00264144
R5722 VGND.n1568 VGND.n706 0.00264144
R5723 VGND.n1568 VGND.n1567 0.00264144
R5724 VGND.n1567 VGND.n1566 0.00264144
R5725 VGND.n1566 VGND.n711 0.00264144
R5726 VGND.n1557 VGND.n711 0.00264144
R5727 VGND.n1558 VGND.n1557 0.00264144
R5728 VGND.n1558 VGND.n1556 0.00264144
R5729 VGND.n1556 VGND.n1555 0.00264144
R5730 VGND.n1552 VGND.n717 0.00264144
R5731 VGND.n1545 VGND.n717 0.00264144
R5732 VGND.n1545 VGND.n1544 0.00264144
R5733 VGND.n1544 VGND.n1543 0.00264144
R5734 VGND.n1543 VGND.n722 0.00264144
R5735 VGND.n1534 VGND.n722 0.00264144
R5736 VGND.n1535 VGND.n1534 0.00264144
R5737 VGND.n1535 VGND.n1533 0.00264144
R5738 VGND.n1533 VGND.n1532 0.00264144
R5739 VGND.n1532 VGND.n728 0.00264144
R5740 VGND.n1523 VGND.n728 0.00264144
R5741 VGND.n1524 VGND.n1523 0.00264144
R5742 VGND.n1524 VGND.n1522 0.00264144
R5743 VGND.n1522 VGND.n1521 0.00264144
R5744 VGND.n1521 VGND.n734 0.00264144
R5745 VGND.n1512 VGND.n734 0.00264144
R5746 VGND.n1513 VGND.n1512 0.00264144
R5747 VGND.n1513 VGND.n1511 0.00264144
R5748 VGND.n1511 VGND.n1510 0.00264144
R5749 VGND.n1510 VGND.n740 0.00264144
R5750 VGND.n1501 VGND.n740 0.00264144
R5751 VGND.n1502 VGND.n1501 0.00264144
R5752 VGND.n1502 VGND.n1500 0.00264144
R5753 VGND.n1500 VGND.n1499 0.00264144
R5754 VGND.n1499 VGND.n746 0.00264144
R5755 VGND.n1490 VGND.n746 0.00264144
R5756 VGND.n1491 VGND.n1490 0.00264144
R5757 VGND.n1491 VGND.n1489 0.00264144
R5758 VGND.n1489 VGND.n1488 0.00264144
R5759 VGND.n1488 VGND.n752 0.00264144
R5760 VGND.n1479 VGND.n752 0.00264144
R5761 VGND.n1480 VGND.n1479 0.00264144
R5762 VGND.n1480 VGND.n1478 0.00264144
R5763 VGND.n1478 VGND.n1477 0.00264144
R5764 VGND.n1477 VGND.n758 0.00264144
R5765 VGND.n1419 VGND.n758 0.00264144
R5766 VGND.n1420 VGND.n1419 0.00264144
R5767 VGND.n1420 VGND.n1418 0.00264144
R5768 VGND.n1418 VGND.n1417 0.00264144
R5769 VGND.n1417 VGND.n792 0.00264144
R5770 VGND.n1408 VGND.n792 0.00264144
R5771 VGND.n1408 VGND.n1407 0.00264144
R5772 VGND.n1407 VGND.n1406 0.00264144
R5773 VGND.n1406 VGND.n801 0.00264144
R5774 VGND.n1398 VGND.n801 0.00264144
R5775 VGND.n1399 VGND.n1398 0.00264144
R5776 VGND.n1399 VGND.n1397 0.00264144
R5777 VGND.n1397 VGND.n1396 0.00264144
R5778 VGND.n1396 VGND.n811 0.00264144
R5779 VGND.n1389 VGND.n811 0.00264144
R5780 VGND.n1389 VGND.n1388 0.00264144
R5781 VGND.n1388 VGND.n1387 0.00264144
R5782 VGND.n1387 VGND.n820 0.00264144
R5783 VGND.n1379 VGND.n820 0.00264144
R5784 VGND.n1380 VGND.n1379 0.00264144
R5785 VGND.n1380 VGND.n1378 0.00264144
R5786 VGND.n1378 VGND.n1377 0.00264144
R5787 VGND.n1377 VGND.n826 0.00264144
R5788 VGND.n1370 VGND.n826 0.00264144
R5789 VGND.n1370 VGND.n1369 0.00264144
R5790 VGND.n2070 VGND.n377 0.00264144
R5791 VGND.n1792 VGND.n377 0.00264144
R5792 VGND.n1792 VGND.n1755 0.00264144
R5793 VGND.n1796 VGND.n1755 0.00264144
R5794 VGND.n1797 VGND.n1796 0.00264144
R5795 VGND.n1798 VGND.n1797 0.00264144
R5796 VGND.n1798 VGND.n1750 0.00264144
R5797 VGND.n1802 VGND.n1750 0.00264144
R5798 VGND.n1803 VGND.n1802 0.00264144
R5799 VGND.n1804 VGND.n1803 0.00264144
R5800 VGND.n1804 VGND.n1745 0.00264144
R5801 VGND.n1808 VGND.n1745 0.00264144
R5802 VGND.n1809 VGND.n1808 0.00264144
R5803 VGND.n1810 VGND.n1809 0.00264144
R5804 VGND.n1810 VGND.n1740 0.00264144
R5805 VGND.n1814 VGND.n1740 0.00264144
R5806 VGND.n1815 VGND.n1814 0.00264144
R5807 VGND.n1816 VGND.n1815 0.00264144
R5808 VGND.n1816 VGND.n1735 0.00264144
R5809 VGND.n1820 VGND.n1735 0.00264144
R5810 VGND.n1821 VGND.n1820 0.00264144
R5811 VGND.n1822 VGND.n1821 0.00264144
R5812 VGND.n1822 VGND.n1730 0.00264144
R5813 VGND.n1826 VGND.n1730 0.00264144
R5814 VGND.n1827 VGND.n1826 0.00264144
R5815 VGND.n1828 VGND.n1827 0.00264144
R5816 VGND.n1828 VGND.n1725 0.00264144
R5817 VGND.n1832 VGND.n1725 0.00264144
R5818 VGND.n1833 VGND.n1832 0.00264144
R5819 VGND.n1834 VGND.n1833 0.00264144
R5820 VGND.n1834 VGND.n1720 0.00264144
R5821 VGND.n1838 VGND.n1720 0.00264144
R5822 VGND.n1839 VGND.n1838 0.00264144
R5823 VGND.n1840 VGND.n1839 0.00264144
R5824 VGND.n1840 VGND.n1715 0.00264144
R5825 VGND.n1844 VGND.n1715 0.00264144
R5826 VGND.n1845 VGND.n1844 0.00264144
R5827 VGND.n1846 VGND.n1845 0.00264144
R5828 VGND.n1846 VGND.n1710 0.00264144
R5829 VGND.n1850 VGND.n1710 0.00264144
R5830 VGND.n1851 VGND.n1850 0.00264144
R5831 VGND.n1852 VGND.n1851 0.00264144
R5832 VGND.n1852 VGND.n1705 0.00264144
R5833 VGND.n1856 VGND.n1705 0.00264144
R5834 VGND.n1857 VGND.n1856 0.00264144
R5835 VGND.n1858 VGND.n1857 0.00264144
R5836 VGND.n1858 VGND.n1700 0.00264144
R5837 VGND.n1862 VGND.n1700 0.00264144
R5838 VGND.n1863 VGND.n1862 0.00264144
R5839 VGND.n1864 VGND.n1863 0.00264144
R5840 VGND.n1864 VGND.n1695 0.00264144
R5841 VGND.n1868 VGND.n1695 0.00264144
R5842 VGND.n1869 VGND.n1868 0.00264144
R5843 VGND.n1870 VGND.n1869 0.00264144
R5844 VGND.n1870 VGND.n1690 0.00264144
R5845 VGND.n1874 VGND.n1690 0.00264144
R5846 VGND.n1875 VGND.n1874 0.00264144
R5847 VGND.n1876 VGND.n1875 0.00264144
R5848 VGND.n1876 VGND.n1685 0.00264144
R5849 VGND.n1880 VGND.n1685 0.00264144
R5850 VGND.n1881 VGND.n1880 0.00264144
R5851 VGND.n1882 VGND.n1881 0.00264144
R5852 VGND.n2069 VGND.n378 0.00264144
R5853 VGND.n1791 VGND.n378 0.00264144
R5854 VGND.n1791 VGND.n1756 0.00264144
R5855 VGND.n1756 VGND.n1754 0.00264144
R5856 VGND.n1754 VGND.n1753 0.00264144
R5857 VGND.n1753 VGND.n1752 0.00264144
R5858 VGND.n1788 VGND.n1752 0.00264144
R5859 VGND.n1788 VGND.n1749 0.00264144
R5860 VGND.n1749 VGND.n1748 0.00264144
R5861 VGND.n1748 VGND.n1747 0.00264144
R5862 VGND.n1785 VGND.n1747 0.00264144
R5863 VGND.n1785 VGND.n1744 0.00264144
R5864 VGND.n1744 VGND.n1743 0.00264144
R5865 VGND.n1743 VGND.n1742 0.00264144
R5866 VGND.n1757 VGND.n1742 0.00264144
R5867 VGND.n1757 VGND.n1739 0.00264144
R5868 VGND.n1739 VGND.n1738 0.00264144
R5869 VGND.n1738 VGND.n1737 0.00264144
R5870 VGND.n1782 VGND.n1737 0.00264144
R5871 VGND.n1782 VGND.n1734 0.00264144
R5872 VGND.n1734 VGND.n1733 0.00264144
R5873 VGND.n1733 VGND.n1732 0.00264144
R5874 VGND.n1779 VGND.n1732 0.00264144
R5875 VGND.n1779 VGND.n1729 0.00264144
R5876 VGND.n1729 VGND.n1728 0.00264144
R5877 VGND.n1728 VGND.n1727 0.00264144
R5878 VGND.n1758 VGND.n1727 0.00264144
R5879 VGND.n1758 VGND.n1724 0.00264144
R5880 VGND.n1724 VGND.n1723 0.00264144
R5881 VGND.n1723 VGND.n1722 0.00264144
R5882 VGND.n1776 VGND.n1722 0.00264144
R5883 VGND.n1776 VGND.n1719 0.00264144
R5884 VGND.n1719 VGND.n1718 0.00264144
R5885 VGND.n1718 VGND.n1717 0.00264144
R5886 VGND.n1773 VGND.n1717 0.00264144
R5887 VGND.n1773 VGND.n1714 0.00264144
R5888 VGND.n1714 VGND.n1713 0.00264144
R5889 VGND.n1713 VGND.n1712 0.00264144
R5890 VGND.n1759 VGND.n1712 0.00264144
R5891 VGND.n1759 VGND.n1709 0.00264144
R5892 VGND.n1709 VGND.n1708 0.00264144
R5893 VGND.n1708 VGND.n1707 0.00264144
R5894 VGND.n1770 VGND.n1707 0.00264144
R5895 VGND.n1770 VGND.n1704 0.00264144
R5896 VGND.n1704 VGND.n1703 0.00264144
R5897 VGND.n1703 VGND.n1702 0.00264144
R5898 VGND.n1767 VGND.n1702 0.00264144
R5899 VGND.n1767 VGND.n1699 0.00264144
R5900 VGND.n1699 VGND.n1698 0.00264144
R5901 VGND.n1698 VGND.n1697 0.00264144
R5902 VGND.n1760 VGND.n1697 0.00264144
R5903 VGND.n1760 VGND.n1694 0.00264144
R5904 VGND.n1694 VGND.n1693 0.00264144
R5905 VGND.n1693 VGND.n1692 0.00264144
R5906 VGND.n1764 VGND.n1692 0.00264144
R5907 VGND.n1764 VGND.n1689 0.00264144
R5908 VGND.n1689 VGND.n1688 0.00264144
R5909 VGND.n1688 VGND.n1687 0.00264144
R5910 VGND.n1761 VGND.n1687 0.00264144
R5911 VGND.n1761 VGND.n1684 0.00264144
R5912 VGND.n1684 VGND.n1683 0.00264144
R5913 VGND.n1683 VGND.n1682 0.00264144
R5914 VGND.n2068 VGND.n306 0.00264144
R5915 VGND.n115 VGND.n306 0.00206464
R5916 VGND.n1790 VGND.n304 0.00264144
R5917 VGND.n116 VGND.n304 0.00206464
R5918 VGND.n305 VGND.n1789 0.00264144
R5919 VGND.n1789 VGND.n303 0.00206464
R5920 VGND.n351 VGND.n350 0.00264144
R5921 VGND.n351 VGND.n114 0.00206464
R5922 VGND.n1787 VGND.n301 0.00264144
R5923 VGND.n113 VGND.n301 0.00206464
R5924 VGND.n302 VGND.n1786 0.00264144
R5925 VGND.n1786 VGND.n300 0.00206464
R5926 VGND.n353 VGND.n352 0.00264144
R5927 VGND.n353 VGND.n112 0.00206464
R5928 VGND.n1784 VGND.n298 0.00264144
R5929 VGND.n109 VGND.n298 0.00206464
R5930 VGND.n299 VGND.n1783 0.00264144
R5931 VGND.n1783 VGND.n297 0.00206464
R5932 VGND.n355 VGND.n354 0.00264144
R5933 VGND.n355 VGND.n107 0.00206464
R5934 VGND.n1781 VGND.n295 0.00264144
R5935 VGND.n108 VGND.n295 0.00206464
R5936 VGND.n296 VGND.n1780 0.00264144
R5937 VGND.n1780 VGND.n294 0.00206464
R5938 VGND.n357 VGND.n356 0.00264144
R5939 VGND.n357 VGND.n110 0.00206464
R5940 VGND.n1778 VGND.n292 0.00264144
R5941 VGND.n111 VGND.n292 0.00206464
R5942 VGND.n293 VGND.n1777 0.00264144
R5943 VGND.n1777 VGND.n291 0.00206464
R5944 VGND.n359 VGND.n358 0.00264144
R5945 VGND.n359 VGND.n119 0.00206464
R5946 VGND.n1775 VGND.n289 0.00264144
R5947 VGND.n118 VGND.n289 0.00206464
R5948 VGND.n290 VGND.n1774 0.00264144
R5949 VGND.n1774 VGND.n288 0.00206464
R5950 VGND.n361 VGND.n360 0.00264144
R5951 VGND.n361 VGND.n117 0.00206464
R5952 VGND.n1772 VGND.n286 0.00264144
R5953 VGND.n120 VGND.n286 0.00206464
R5954 VGND.n287 VGND.n1771 0.00264144
R5955 VGND.n1771 VGND.n285 0.00206464
R5956 VGND.n363 VGND.n362 0.00264144
R5957 VGND.n363 VGND.n122 0.00206464
R5958 VGND.n1769 VGND.n283 0.00264144
R5959 VGND.n121 VGND.n283 0.00206464
R5960 VGND.n284 VGND.n1768 0.00264144
R5961 VGND.n1768 VGND.n282 0.00206464
R5962 VGND.n365 VGND.n364 0.00264144
R5963 VGND.n365 VGND.n125 0.00206464
R5964 VGND.n1766 VGND.n280 0.00264144
R5965 VGND.n124 VGND.n280 0.00206464
R5966 VGND.n281 VGND.n1765 0.00264144
R5967 VGND.n1765 VGND.n279 0.00206464
R5968 VGND.n367 VGND.n366 0.00264144
R5969 VGND.n367 VGND.n126 0.00206464
R5970 VGND.n1763 VGND.n277 0.00264144
R5971 VGND.n127 VGND.n277 0.00206464
R5972 VGND.n278 VGND.n1762 0.00264144
R5973 VGND.n1762 VGND.n276 0.00206464
R5974 VGND.n369 VGND.n368 0.00264144
R5975 VGND.n369 VGND.n128 0.00206464
R5976 VGND.n123 VGND.n248 0.00206464
R5977 VGND.n1886 VGND.n248 0.00264144
R5978 VGND.n229 VGND.n1886 0.00264144
R5979 VGND.n100 VGND.n228 0.00206464
R5980 VGND.n1887 VGND.n228 0.00264144
R5981 VGND.n240 VGND.n1887 0.00206464
R5982 VGND.n244 VGND.n251 0.00264144
R5983 VGND.n103 VGND.n251 0.00206464
R5984 VGND.n1889 VGND.n1888 0.00264144
R5985 VGND.n259 VGND.n638 0.00206464
R5986 VGND.n1662 VGND.n638 0.00264144
R5987 VGND.n1662 VGND.n263 0.00206464
R5988 VGND.n1661 VGND.n258 0.00264144
R5989 VGND.n1660 VGND.n105 0.00206464
R5990 VGND.n1660 VGND.n257 0.00264144
R5991 VGND.n1649 VGND.n256 0.00206464
R5992 VGND.n1649 VGND.n254 0.00264144
R5993 VGND.n1648 VGND.n104 0.00206464
R5994 VGND.n1648 VGND.n250 0.00264144
R5995 VGND.n1639 VGND.n247 0.00206464
R5996 VGND.n1639 VGND.n242 0.00264144
R5997 VGND.n102 VGND.n242 0.00206464
R5998 VGND.n243 VGND.n236 0.00264144
R5999 VGND.n1631 VGND.n235 0.00206464
R6000 VGND.n1631 VGND.n232 0.00264144
R6001 VGND.n101 VGND.n232 0.00206464
R6002 VGND.n233 VGND.n227 0.00264144
R6003 VGND.n1623 VGND.n226 0.00206464
R6004 VGND.n1623 VGND.n222 0.00264144
R6005 VGND.n106 VGND.n222 0.00206464
R6006 VGND.n223 VGND.n225 0.00264144
R6007 VGND.n82 VGND.n225 0.00206464
R6008 VGND.n1615 VGND.n230 0.00264144
R6009 VGND.n99 VGND.n230 0.00206464
R6010 VGND.n231 VGND.n234 0.00264144
R6011 VGND.n98 VGND.n234 0.00206464
R6012 VGND.n1607 VGND.n237 0.00264144
R6013 VGND.n239 VGND.n97 0.00206464
R6014 VGND.n239 VGND.n686 0.00264144
R6015 VGND.n1599 VGND.n241 0.00206464
R6016 VGND.n1599 VGND.n245 0.00264144
R6017 VGND.n96 VGND.n245 0.00206464
R6018 VGND.n246 VGND.n692 0.00264144
R6019 VGND.n1591 VGND.n328 0.00206464
R6020 VGND.n1591 VGND.n95 0.00264144
R6021 VGND.n1590 VGND.n95 0.00264144
R6022 VGND.n326 VGND.n1590 0.00206464
R6023 VGND.n336 VGND.n338 0.00264144
R6024 VGND.n1581 VGND.n262 0.00206464
R6025 VGND.n1581 VGND.n322 0.00264144
R6026 VGND.n94 VGND.n322 0.00206464
R6027 VGND.n323 VGND.n320 0.00264144
R6028 VGND.n93 VGND.n320 0.00206464
R6029 VGND.n1572 VGND.n318 0.00264144
R6030 VGND.n92 VGND.n318 0.00206464
R6031 VGND.n342 VGND.n1571 0.00264144
R6032 VGND.n342 VGND.n91 0.00206464
R6033 VGND.n1562 VGND.n316 0.00264144
R6034 VGND.n1562 VGND.n314 0.00206464
R6035 VGND.n1561 VGND.n344 0.00264144
R6036 VGND.n312 VGND.n1561 0.00206464
R6037 VGND.n346 VGND.n83 0.00264144
R6038 VGND.n249 VGND.n645 0.00264144
R6039 VGND.n645 VGND.n644 0.00264144
R6040 VGND.n644 VGND.n643 0.00264144
R6041 VGND.n649 VGND.n643 0.00264144
R6042 VGND.n649 VGND.n642 0.00264144
R6043 VGND.n642 VGND.n641 0.00264144
R6044 VGND.n1670 VGND.n641 0.00264144
R6045 VGND.n1670 VGND.n640 0.00264144
R6046 VGND.n640 VGND.n639 0.00264144
R6047 VGND.n1664 VGND.n639 0.00264144
R6048 VGND.n1664 VGND.n1663 0.00264144
R6049 VGND.n1663 VGND.n654 0.00264144
R6050 VGND.n1658 VGND.n654 0.00264144
R6051 VGND.n1659 VGND.n1658 0.00264144
R6052 VGND.n1659 VGND.n655 0.00264144
R6053 VGND.n1650 VGND.n655 0.00264144
R6054 VGND.n1650 VGND.n660 0.00264144
R6055 VGND.n1647 VGND.n660 0.00264144
R6056 VGND.n1647 VGND.n661 0.00264144
R6057 VGND.n1640 VGND.n661 0.00264144
R6058 VGND.n1640 VGND.n665 0.00264144
R6059 VGND.n1638 VGND.n665 0.00264144
R6060 VGND.n1638 VGND.n666 0.00264144
R6061 VGND.n1632 VGND.n666 0.00264144
R6062 VGND.n1632 VGND.n670 0.00264144
R6063 VGND.n1630 VGND.n670 0.00264144
R6064 VGND.n1630 VGND.n671 0.00264144
R6065 VGND.n1624 VGND.n671 0.00264144
R6066 VGND.n1624 VGND.n675 0.00264144
R6067 VGND.n1622 VGND.n675 0.00264144
R6068 VGND.n1622 VGND.n676 0.00264144
R6069 VGND.n1616 VGND.n676 0.00264144
R6070 VGND.n1616 VGND.n680 0.00264144
R6071 VGND.n1614 VGND.n680 0.00264144
R6072 VGND.n1614 VGND.n681 0.00264144
R6073 VGND.n1608 VGND.n681 0.00264144
R6074 VGND.n1608 VGND.n685 0.00264144
R6075 VGND.n1606 VGND.n685 0.00264144
R6076 VGND.n1606 VGND.n687 0.00264144
R6077 VGND.n1600 VGND.n687 0.00264144
R6078 VGND.n1600 VGND.n691 0.00264144
R6079 VGND.n1598 VGND.n691 0.00264144
R6080 VGND.n1598 VGND.n693 0.00264144
R6081 VGND.n1592 VGND.n693 0.00264144
R6082 VGND.n1592 VGND.n697 0.00264144
R6083 VGND.n1589 VGND.n697 0.00264144
R6084 VGND.n1589 VGND.n698 0.00264144
R6085 VGND.n1583 VGND.n698 0.00264144
R6086 VGND.n1583 VGND.n1582 0.00264144
R6087 VGND.n1582 VGND.n702 0.00264144
R6088 VGND.n1580 VGND.n702 0.00264144
R6089 VGND.n1580 VGND.n703 0.00264144
R6090 VGND.n1573 VGND.n703 0.00264144
R6091 VGND.n1573 VGND.n708 0.00264144
R6092 VGND.n1570 VGND.n708 0.00264144
R6093 VGND.n1570 VGND.n709 0.00264144
R6094 VGND.n1564 VGND.n709 0.00264144
R6095 VGND.n1564 VGND.n1563 0.00264144
R6096 VGND.n1563 VGND.n713 0.00264144
R6097 VGND.n1560 VGND.n713 0.00264144
R6098 VGND.n1560 VGND.n714 0.00264144
R6099 VGND.n1553 VGND.n714 0.00264144
R6100 VGND.n1885 VGND.n646 0.00264144
R6101 VGND.n1678 VGND.n646 0.00264144
R6102 VGND.n1678 VGND.n1677 0.00264144
R6103 VGND.n1677 VGND.n1676 0.00264144
R6104 VGND.n1676 VGND.n648 0.00264144
R6105 VGND.n1672 VGND.n648 0.00264144
R6106 VGND.n1672 VGND.n1671 0.00264144
R6107 VGND.n1671 VGND.n1669 0.00264144
R6108 VGND.n1669 VGND.n651 0.00264144
R6109 VGND.n1665 VGND.n651 0.00264144
R6110 VGND.n1665 VGND.n653 0.00264144
R6111 VGND.n657 VGND.n653 0.00264144
R6112 VGND.n1657 VGND.n657 0.00264144
R6113 VGND.n1657 VGND.n656 0.00264144
R6114 VGND.n1652 VGND.n656 0.00264144
R6115 VGND.n1652 VGND.n1651 0.00264144
R6116 VGND.n1651 VGND.n659 0.00264144
R6117 VGND.n1646 VGND.n659 0.00264144
R6118 VGND.n1646 VGND.n662 0.00264144
R6119 VGND.n1641 VGND.n662 0.00264144
R6120 VGND.n1641 VGND.n664 0.00264144
R6121 VGND.n1637 VGND.n664 0.00264144
R6122 VGND.n1637 VGND.n667 0.00264144
R6123 VGND.n1633 VGND.n667 0.00264144
R6124 VGND.n1633 VGND.n669 0.00264144
R6125 VGND.n1629 VGND.n669 0.00264144
R6126 VGND.n1629 VGND.n672 0.00264144
R6127 VGND.n1625 VGND.n672 0.00264144
R6128 VGND.n1625 VGND.n674 0.00264144
R6129 VGND.n1621 VGND.n674 0.00264144
R6130 VGND.n1621 VGND.n677 0.00264144
R6131 VGND.n1617 VGND.n677 0.00264144
R6132 VGND.n1617 VGND.n679 0.00264144
R6133 VGND.n1613 VGND.n679 0.00264144
R6134 VGND.n1613 VGND.n682 0.00264144
R6135 VGND.n1609 VGND.n682 0.00264144
R6136 VGND.n1609 VGND.n684 0.00264144
R6137 VGND.n1605 VGND.n684 0.00264144
R6138 VGND.n1605 VGND.n688 0.00264144
R6139 VGND.n1601 VGND.n688 0.00264144
R6140 VGND.n1601 VGND.n690 0.00264144
R6141 VGND.n1597 VGND.n690 0.00264144
R6142 VGND.n1597 VGND.n694 0.00264144
R6143 VGND.n1593 VGND.n694 0.00264144
R6144 VGND.n1593 VGND.n696 0.00264144
R6145 VGND.n1588 VGND.n696 0.00264144
R6146 VGND.n1588 VGND.n699 0.00264144
R6147 VGND.n1584 VGND.n699 0.00264144
R6148 VGND.n1584 VGND.n701 0.00264144
R6149 VGND.n705 VGND.n701 0.00264144
R6150 VGND.n1579 VGND.n705 0.00264144
R6151 VGND.n1579 VGND.n704 0.00264144
R6152 VGND.n1574 VGND.n704 0.00264144
R6153 VGND.n1574 VGND.n707 0.00264144
R6154 VGND.n1569 VGND.n707 0.00264144
R6155 VGND.n1569 VGND.n710 0.00264144
R6156 VGND.n1565 VGND.n710 0.00264144
R6157 VGND.n1565 VGND.n712 0.00264144
R6158 VGND.n716 VGND.n712 0.00264144
R6159 VGND.n1559 VGND.n716 0.00264144
R6160 VGND.n1559 VGND.n715 0.00264144
R6161 VGND.n1554 VGND.n715 0.00264144
R6162 VGND.n1549 VGND.n335 0.00264144
R6163 VGND.n1548 VGND.n329 0.00206464
R6164 VGND.n332 VGND.n1548 0.00264144
R6165 VGND.n84 VGND.n331 0.00206464
R6166 VGND.n1539 VGND.n331 0.00264144
R6167 VGND.n86 VGND.n333 0.00206464
R6168 VGND.n1538 VGND.n333 0.00264144
R6169 VGND.n334 VGND.n1538 0.00264144
R6170 VGND.n334 VGND.n85 0.00206464
R6171 VGND.n1528 VGND.n330 0.00264144
R6172 VGND.n1528 VGND.n327 0.00264144
R6173 VGND.n87 VGND.n327 0.00206464
R6174 VGND.n337 VGND.n1527 0.00264144
R6175 VGND.n337 VGND.n88 0.00206464
R6176 VGND.n1517 VGND.n325 0.00264144
R6177 VGND.n1517 VGND.n324 0.00206464
R6178 VGND.n1516 VGND.n339 0.00264144
R6179 VGND.n321 VGND.n1516 0.00206464
R6180 VGND.n340 VGND.n319 0.00264144
R6181 VGND.n90 VGND.n319 0.00206464
R6182 VGND.n1506 VGND.n317 0.00264144
R6183 VGND.n89 VGND.n317 0.00206464
R6184 VGND.n343 VGND.n1505 0.00264144
R6185 VGND.n343 VGND.n69 0.00206464
R6186 VGND.n1495 VGND.n315 0.00264144
R6187 VGND.n1495 VGND.n313 0.00206464
R6188 VGND.n1494 VGND.n345 0.00264144
R6189 VGND.n311 VGND.n1494 0.00206464
R6190 VGND.n347 VGND.n310 0.00264144
R6191 VGND.n70 VGND.n310 0.00206464
R6192 VGND.n1484 VGND.n308 0.00264144
R6193 VGND.n71 VGND.n308 0.00206464
R6194 VGND.n341 VGND.n1483 0.00264144
R6195 VGND.n341 VGND.n72 0.00206464
R6196 VGND.n1473 VGND.n269 0.00264144
R6197 VGND.n1473 VGND.n267 0.00264144
R6198 VGND.n349 VGND.n73 0.00206464
R6199 VGND.n349 VGND.n307 0.00264144
R6200 VGND.n74 VGND.n307 0.00206464
R6201 VGND.n1414 VGND.n75 0.00264144
R6202 VGND.n1411 VGND.n75 0.00264144
R6203 VGND.n309 VGND.n1411 0.00206464
R6204 VGND.n348 VGND.n268 0.00264144
R6205 VGND.n76 VGND.n268 0.00206464
R6206 VGND.n1402 VGND.n78 0.00264144
R6207 VGND.n266 VGND.n78 0.00264144
R6208 VGND.n77 VGND.n265 0.00206464
R6209 VGND.n1393 VGND.n265 0.00264144
R6210 VGND.n1393 VGND.n275 0.00206464
R6211 VGND.n1392 VGND.n371 0.00264144
R6212 VGND.n374 VGND.n79 0.00206464
R6213 VGND.n374 VGND.n370 0.00264144
R6214 VGND.n1383 VGND.n264 0.00206464
R6215 VGND.n1383 VGND.n270 0.00264144
R6216 VGND.n375 VGND.n80 0.00206464
R6217 VGND.n375 VGND.n373 0.00264144
R6218 VGND.n1374 VGND.n271 0.00206464
R6219 VGND.n1374 VGND.n372 0.00264144
R6220 VGND.n1373 VGND.n272 0.00206464
R6221 VGND.n274 VGND.n1373 0.00264144
R6222 VGND.n81 VGND.n273 0.00206464
R6223 VGND.n1364 VGND.n273 0.00264144
R6224 VGND.n1550 VGND.n719 0.00264144
R6225 VGND.n1547 VGND.n719 0.00264144
R6226 VGND.n1547 VGND.n720 0.00264144
R6227 VGND.n1541 VGND.n720 0.00264144
R6228 VGND.n1541 VGND.n1540 0.00264144
R6229 VGND.n1540 VGND.n724 0.00264144
R6230 VGND.n1537 VGND.n724 0.00264144
R6231 VGND.n1537 VGND.n725 0.00264144
R6232 VGND.n1530 VGND.n725 0.00264144
R6233 VGND.n1530 VGND.n1529 0.00264144
R6234 VGND.n1529 VGND.n730 0.00264144
R6235 VGND.n1526 VGND.n730 0.00264144
R6236 VGND.n1526 VGND.n731 0.00264144
R6237 VGND.n1519 VGND.n731 0.00264144
R6238 VGND.n1519 VGND.n1518 0.00264144
R6239 VGND.n1518 VGND.n736 0.00264144
R6240 VGND.n1515 VGND.n736 0.00264144
R6241 VGND.n1515 VGND.n737 0.00264144
R6242 VGND.n1508 VGND.n737 0.00264144
R6243 VGND.n1508 VGND.n1507 0.00264144
R6244 VGND.n1507 VGND.n742 0.00264144
R6245 VGND.n1504 VGND.n742 0.00264144
R6246 VGND.n1504 VGND.n743 0.00264144
R6247 VGND.n1497 VGND.n743 0.00264144
R6248 VGND.n1497 VGND.n1496 0.00264144
R6249 VGND.n1496 VGND.n748 0.00264144
R6250 VGND.n1493 VGND.n748 0.00264144
R6251 VGND.n1493 VGND.n749 0.00264144
R6252 VGND.n1486 VGND.n749 0.00264144
R6253 VGND.n1486 VGND.n1485 0.00264144
R6254 VGND.n1485 VGND.n754 0.00264144
R6255 VGND.n1482 VGND.n754 0.00264144
R6256 VGND.n1482 VGND.n755 0.00264144
R6257 VGND.n1475 VGND.n755 0.00264144
R6258 VGND.n1475 VGND.n1474 0.00264144
R6259 VGND.n1474 VGND.n760 0.00264144
R6260 VGND.n1422 VGND.n760 0.00264144
R6261 VGND.n1422 VGND.n789 0.00264144
R6262 VGND.n1415 VGND.n789 0.00264144
R6263 VGND.n1415 VGND.n794 0.00264144
R6264 VGND.n1410 VGND.n794 0.00264144
R6265 VGND.n1410 VGND.n799 0.00264144
R6266 VGND.n1404 VGND.n799 0.00264144
R6267 VGND.n1404 VGND.n1403 0.00264144
R6268 VGND.n1403 VGND.n803 0.00264144
R6269 VGND.n1401 VGND.n803 0.00264144
R6270 VGND.n1401 VGND.n808 0.00264144
R6271 VGND.n1394 VGND.n808 0.00264144
R6272 VGND.n1394 VGND.n813 0.00264144
R6273 VGND.n1391 VGND.n813 0.00264144
R6274 VGND.n1391 VGND.n818 0.00264144
R6275 VGND.n1385 VGND.n818 0.00264144
R6276 VGND.n1385 VGND.n1384 0.00264144
R6277 VGND.n1384 VGND.n822 0.00264144
R6278 VGND.n1382 VGND.n822 0.00264144
R6279 VGND.n1382 VGND.n823 0.00264144
R6280 VGND.n1375 VGND.n823 0.00264144
R6281 VGND.n1375 VGND.n828 0.00264144
R6282 VGND.n1372 VGND.n828 0.00264144
R6283 VGND.n1372 VGND.n829 0.00264144
R6284 VGND.n1366 VGND.n829 0.00264144
R6285 VGND.n1366 VGND.n1365 0.00264144
R6286 VGND.n1551 VGND.n718 0.00264144
R6287 VGND.n1546 VGND.n718 0.00264144
R6288 VGND.n1546 VGND.n721 0.00264144
R6289 VGND.n1542 VGND.n721 0.00264144
R6290 VGND.n1542 VGND.n723 0.00264144
R6291 VGND.n727 VGND.n723 0.00264144
R6292 VGND.n1536 VGND.n727 0.00264144
R6293 VGND.n1536 VGND.n726 0.00264144
R6294 VGND.n1531 VGND.n726 0.00264144
R6295 VGND.n1531 VGND.n729 0.00264144
R6296 VGND.n733 VGND.n729 0.00264144
R6297 VGND.n1525 VGND.n733 0.00264144
R6298 VGND.n1525 VGND.n732 0.00264144
R6299 VGND.n1520 VGND.n732 0.00264144
R6300 VGND.n1520 VGND.n735 0.00264144
R6301 VGND.n739 VGND.n735 0.00264144
R6302 VGND.n1514 VGND.n739 0.00264144
R6303 VGND.n1514 VGND.n738 0.00264144
R6304 VGND.n1509 VGND.n738 0.00264144
R6305 VGND.n1509 VGND.n741 0.00264144
R6306 VGND.n745 VGND.n741 0.00264144
R6307 VGND.n1503 VGND.n745 0.00264144
R6308 VGND.n1503 VGND.n744 0.00264144
R6309 VGND.n1498 VGND.n744 0.00264144
R6310 VGND.n1498 VGND.n747 0.00264144
R6311 VGND.n751 VGND.n747 0.00264144
R6312 VGND.n1492 VGND.n751 0.00264144
R6313 VGND.n1492 VGND.n750 0.00264144
R6314 VGND.n1487 VGND.n750 0.00264144
R6315 VGND.n1487 VGND.n753 0.00264144
R6316 VGND.n757 VGND.n753 0.00264144
R6317 VGND.n1481 VGND.n757 0.00264144
R6318 VGND.n1481 VGND.n756 0.00264144
R6319 VGND.n1476 VGND.n756 0.00264144
R6320 VGND.n1476 VGND.n759 0.00264144
R6321 VGND.n791 VGND.n759 0.00264144
R6322 VGND.n1421 VGND.n791 0.00264144
R6323 VGND.n1421 VGND.n790 0.00264144
R6324 VGND.n1416 VGND.n790 0.00264144
R6325 VGND.n1416 VGND.n793 0.00264144
R6326 VGND.n1409 VGND.n793 0.00264144
R6327 VGND.n1409 VGND.n800 0.00264144
R6328 VGND.n1405 VGND.n800 0.00264144
R6329 VGND.n1405 VGND.n802 0.00264144
R6330 VGND.n810 VGND.n802 0.00264144
R6331 VGND.n1400 VGND.n810 0.00264144
R6332 VGND.n1400 VGND.n809 0.00264144
R6333 VGND.n1395 VGND.n809 0.00264144
R6334 VGND.n1395 VGND.n812 0.00264144
R6335 VGND.n1390 VGND.n812 0.00264144
R6336 VGND.n1390 VGND.n819 0.00264144
R6337 VGND.n1386 VGND.n819 0.00264144
R6338 VGND.n1386 VGND.n821 0.00264144
R6339 VGND.n825 VGND.n821 0.00264144
R6340 VGND.n1381 VGND.n825 0.00264144
R6341 VGND.n1381 VGND.n824 0.00264144
R6342 VGND.n1376 VGND.n824 0.00264144
R6343 VGND.n1376 VGND.n827 0.00264144
R6344 VGND.n1371 VGND.n827 0.00264144
R6345 VGND.n1371 VGND.n830 0.00264144
R6346 VGND.n1367 VGND.n830 0.00264144
R6347 VGND.n890 VGND.n884 0.00261088
R6348 VGND.n1197 VGND.n1193 0.00253704
R6349 VGND.n1413 VGND.n1412 0.00253704
R6350 VGND.n773 VGND.n8 0.00253704
R6351 VGND.n1237 VGND.n1227 0.00233333
R6352 VGND.n1351 VGND.n217 0.0300517
R6353 VGND.n1216 VGND.n1210 0.00215116
R6354 VGND.n895 VGND.n882 0.00215062
R6355 VGND.n1198 VGND.n1168 0.00212963
R6356 VGND.n1368 VGND.n1367 0.00205863
R6357 VGND.n1966 VGND.n409 0.00204557
R6358 VGND.n40 VGND.n39 0.00190908
R6359 VGND.n1223 VGND.n41 0.00286357
R6360 VGND.t25 VGND.n429 0.00183814
R6361 VGND.t25 VGND.n428 0.00181165
R6362 VGND.n39 VGND.n1223 0.0010909
R6363 VGND.n130 VGND.n154 0.373045
R6364 VGND.n176 VGND.n174 0.319633
R6365 VGND.n155 VGND.n153 0.178333
R6366 VGND.n213 VGND.n58 0.178333
R6367 VGND.n211 VGND.n213 0.178333
R6368 VGND.n178 VGND.n176 0.226262
R6369 VGND.n180 VGND.n178 0.226262
R6370 VGND.n182 VGND.n180 0.226262
R6371 VGND.n184 VGND.n182 0.226262
R6372 VGND.n186 VGND.n184 0.226262
R6373 VGND.n188 VGND.n186 0.226262
R6374 VGND.n190 VGND.n188 0.226262
R6375 VGND.n192 VGND.n190 0.226262
R6376 VGND.n194 VGND.n192 0.226262
R6377 VGND.n196 VGND.n194 0.226262
R6378 VGND.n198 VGND.n196 0.226262
R6379 VGND.n200 VGND.n198 0.226262
R6380 VGND.n202 VGND.n200 0.226262
R6381 VGND.n204 VGND.n202 0.226262
R6382 VGND.n206 VGND.n204 0.226262
R6383 VGND.n208 VGND.n206 0.226262
R6384 VGND.n210 VGND.n208 0.226262
R6385 VGND.n212 VGND.n210 0.226262
R6386 VGND.n214 VGND.n212 0.226262
R6387 VGND.n215 VGND.n214 0.226262
R6388 VGND.n133 VGND.n131 0.222792
R6389 VGND.n216 VGND.n215 0.198704
R6390 VGND.n209 VGND.n211 0.178333
R6391 VGND.n207 VGND.n209 0.178333
R6392 VGND.n205 VGND.n207 0.178333
R6393 VGND.n203 VGND.n205 0.178333
R6394 VGND.n201 VGND.n203 0.178333
R6395 VGND.n199 VGND.n201 0.178333
R6396 VGND.n197 VGND.n199 0.178333
R6397 VGND.n195 VGND.n197 0.178333
R6398 VGND.n193 VGND.n195 0.178333
R6399 VGND.n191 VGND.n193 0.178333
R6400 VGND.n189 VGND.n191 0.178333
R6401 VGND.n187 VGND.n189 0.178333
R6402 VGND.n185 VGND.n187 0.178333
R6403 VGND.n183 VGND.n185 0.178333
R6404 VGND.n181 VGND.n183 0.178333
R6405 VGND.n179 VGND.n181 0.178333
R6406 VGND.n177 VGND.n179 0.178333
R6407 VGND.n175 VGND.n177 0.178333
R6408 VGND.n171 VGND.n175 0.178333
R6409 VGND.n173 VGND.n171 0.178333
R6410 VGND.n53 VGND.n52 0.178333
R6411 VGND.n52 VGND.n168 0.178333
R6412 VGND.n168 VGND.n166 0.178333
R6413 VGND.n166 VGND.n164 0.178333
R6414 VGND.n164 VGND.n131 0.178333
R6415 VGND.n135 VGND.n133 0.178333
R6416 VGND.n137 VGND.n135 0.178333
R6417 VGND.n139 VGND.n137 0.178333
R6418 VGND.n141 VGND.n139 0.178333
R6419 VGND.n143 VGND.n141 0.178333
R6420 VGND.n145 VGND.n143 0.178333
R6421 VGND.n147 VGND.n145 0.178333
R6422 VGND.n149 VGND.n147 0.178333
R6423 VGND.n151 VGND.n149 0.178333
R6424 VGND.n153 VGND.n151 0.178333
R6425 VGND.n1230 VGND.n53 0.177417
R6426 VGND.n1354 VGND.n58 0.176958
R6427 VGND.n2008 VGND.t19 0.154775
R6428 VGND.t23 VGND.n55 0.115238
R6429 VGND.t38 VGND.n63 0.133537
R6430 VGND.t34 VGND.n60 0.133537
R6431 VGND.t1 VGND.n216 0.0579787
R6432 VGND.n36 VGND.n13 0.0510969
R6433 VGND.n27 VGND.n26 0.0381989
R6434 VGND.n10 VGND.n9 0.0259361
R6435 VGND.n7 VGND.n17 0.017564
R6436 VGND.n15 VGND.n7 0.0137396
R6437 VGND.n20 VGND.n5 0.0136612
R6438 VGND.n19 VGND.n15 0.00755595
R6439 VGND.n28 VGND.n23 0.0124977
R6440 VGND.n21 VGND.n17 0.0124342
R6441 VGND.n4 VGND.n1196 3074.84
C0 a_5691_14086# ua[1] 1.20733f
C1 a_4461_17658# a_4547_17658# 0.01946f
C2 a_12277_17922# a_12277_16894# 0.00868f
C3 a_4548_20952# m3_13650_20824# 0
C4 a_4461_18186# a_4547_18186# 0.01946f
C5 ua[0] w_20495_17056# 0.0381f
C6 ui_in[0] rst_n 0.007f
C7 a_4462_20952# a_4462_20340# 0.00868f
C8 ua[0] VDPWR 53.8489f
C9 a_5691_14643# m3_13650_20824# 0.13887f
C10 a_5691_14086# a_12277_16894# 0.00216f
C11 a_13554_19156# a_4547_16894# 0.00472f
C12 uio_out[7] uio_out[6] 0.007f
C13 ui_in[4] ui_in[3] 0.007f
C14 a_12731_21863# a_12278_21258# 0.00566f
C15 w_15070_19285# m3_13650_20824# 0
C16 a_5691_14086# a_4547_18714# 0.03922f
C17 a_4461_19770# a_4461_17658# 0.01035f
C18 a_5691_14643# a_4547_18450# 0.00431f
C19 uio_oe[3] uio_oe[2] 0.007f
C20 a_4462_20340# VDPWR 0.01043f
C21 uio_in[0] ui_in[7] 0.007f
C22 a_15380_18436# a_12731_21863# 0.00174f
C23 a_4548_20034# a_4548_20340# 0.28316f
C24 a_12277_19506# a_12278_20646# 0
C25 a_4461_19770# a_4548_20646# 0.07627f
C26 a_4548_21871# VDPWR 0.18487f
C27 uio_oe[7] uio_oe[6] 0.007f
C28 ua[1] a_4547_18186# 0.00111f
C29 a_5691_14643# w_4261_13061# 0.04437f
C30 a_13554_19156# w_15070_13306# 0.00549f
C31 a_12277_19506# a_12277_18978# 0.00868f
C32 a_5691_14643# a_4547_19242# 0.01623f
C33 a_16457_19785# a_15380_18436# 2.26037f
C34 a_13554_19156# a_4547_19506# 0
C35 a_5691_14086# VDPWR 7.79357f
C36 a_13554_19156# ua[2] 0.29469f
C37 a_12277_19506# a_13554_19156# 0.0027f
C38 ua[1] a_4462_21565# 0
C39 a_5691_14643# w_15070_19285# 0.02743f
C40 a_13554_19156# w_13200_19935# 0.02901f
C41 a_12277_19506# w_13139_18869# 0
C42 uio_out[3] uio_out[2] 0.007f
C43 a_13554_19156# ua[1] 0.41328f
C44 a_4461_17658# a_4547_17922# 0.01946f
C45 a_4461_18714# a_4461_17658# 0
C46 a_4461_18186# a_4547_18450# 0.01946f
C47 a_4548_20646# a_4548_20340# 0.28316f
C48 w_4261_13061# a_4547_16894# 0
C49 a_15380_18436# ua[0] 0.19848f
C50 a_4548_21258# a_4548_20952# 0.28316f
C51 a_12731_21863# a_4548_20340# 0
C52 a_5691_14643# a_4547_16894# 0.02588f
C53 a_13554_19156# a_12277_16894# 0.0058f
C54 a_12731_21863# a_4548_21565# 0.0122f
C55 a_4462_21565# a_4462_20952# 0.00863f
C56 a_4547_18186# VDPWR 0.0075f
C57 w_13200_19935# m3_13650_20824# 0.00317f
C58 a_13554_19156# a_4547_18714# 0
C59 a_4461_19770# a_12277_17922# 0.01226f
C60 a_12278_20646# VDPWR 0.00109f
C61 uio_in[7] uio_in[6] 0.007f
C62 a_12278_20034# a_4548_20340# 0.02797f
C63 a_4547_19506# a_4547_19242# 0.28316f
C64 a_4462_21565# VDPWR 0.01574f
C65 ua[2] w_4261_13061# 0.0763f
C66 uo_out[3] uo_out[2] 0.007f
C67 a_12277_18978# VDPWR 0.00917f
C68 ua[1] a_4547_18450# 0.00111f
C69 a_5691_14643# w_15070_13306# 0
C70 a_5691_14643# a_4547_19506# 0.00431f
C71 a_5691_14086# a_15380_18436# 1.55585f
C72 a_16457_19785# a_17330_18472# 1.94868f
C73 ua[1] a_4548_20952# 0
C74 a_13554_19156# VDPWR 3.84123f
C75 uo_out[7] uo_out[6] 0.007f
C76 a_5691_14643# ua[2] 2.8893f
C77 w_13139_18869# VDPWR 0.08151f
C78 a_12277_19506# a_5691_14643# 0.00302f
C79 a_4461_19770# a_5691_14086# 0.08942f
C80 ua[1] w_4261_13061# 0.05651f
C81 a_4547_19242# ua[1] 0.00111f
C82 a_5691_14643# w_13200_19935# 0.02162f
C83 a_12278_20034# a_4548_20034# 0.02797f
C84 a_5691_14643# ua[1] 1.47153f
C85 a_12277_17922# a_4547_17922# 0.01946f
C86 a_4547_18714# a_4547_18450# 0.28316f
C87 uio_out[4] uio_out[3] 0.007f
C88 a_4462_20340# a_4548_20340# 0.02797f
C89 a_17330_18472# ua[0] 0.96683f
C90 ui_in[1] ui_in[0] 0.007f
C91 a_12731_21863# a_4548_20646# 0
C92 a_4462_20952# a_4548_20952# 0.02797f
C93 a_12278_21258# a_12278_20646# 0.00868f
C94 m3_13650_20824# VDPWR 0.11496f
C95 a_13554_19156# a_4547_17658# 0
C96 a_12277_18978# a_4547_18978# 0.01946f
C97 a_5691_14643# a_12277_16894# 0.01087f
C98 uio_oe[0] uio_out[7] 0.007f
C99 ui_in[5] ui_in[4] 0.007f
C100 a_4548_21871# a_4548_21565# 0.28316f
C101 a_4547_18450# VDPWR 0.0075f
C102 a_5691_14643# a_4547_18714# 0.00431f
C103 a_13554_19156# a_4547_18978# 0
C104 a_4461_19770# a_4547_18186# 0.25927f
C105 a_4548_20952# VDPWR 0.0906f
C106 uio_oe[4] uio_oe[3] 0.007f
C107 uio_in[1] uio_in[0] 0.007f
C108 ua[1] a_4547_16894# 0.17395f
C109 a_4461_19242# a_4547_19242# 0.01946f
C110 w_4261_13061# VDPWR 0.44117f
C111 ua[2] w_15070_13306# 0.06083f
C112 a_4547_19242# VDPWR 0.00754f
C113 ua[1] a_4461_18186# 0.01151f
C114 rst_n clk 0.007f
C115 a_12278_20034# a_12731_21863# 0
C116 uio_in[4] uio_in[5] 0.007f
C117 a_13554_19156# a_15380_18436# 0.00575f
C118 a_12277_19506# a_4547_19506# 0.01946f
C119 a_5691_14086# a_17330_18472# 1.39141f
C120 a_4461_19770# a_12277_18978# 0.01192f
C121 ua[1] a_4548_21258# 0
C122 a_5691_14643# VDPWR 6.60595f
C123 a_15380_18436# w_13139_18869# 0.00179f
C124 a_4548_20034# a_5691_14086# 0
C125 w_15070_19285# VDPWR 0.97624f
C126 a_4461_19770# a_13554_19156# 0.05218f
C127 ua[1] w_15070_13306# 0.01542f
C128 a_4547_19506# ua[1] 0.00112f
C129 a_4461_19770# w_13139_18869# 0.00196f
C130 a_12277_16894# a_4547_16894# 0.12082f
C131 ua[1] ua[2] 7.80475f
C132 a_4547_18186# a_4547_17922# 0.28316f
C133 clk ena 0.007f
C134 a_4462_20340# a_4548_20646# 0.02797f
C135 uio_in[4] uio_in[3] 0.007f
C136 a_15380_18436# m3_13650_20824# 0
C137 a_16457_19785# ua[0] 1.07996f
C138 a_4547_16894# VDPWR 0.04526f
C139 a_4462_20952# a_4548_21258# 0.02797f
C140 a_13554_19156# a_4547_17922# 0
C141 a_5691_14643# a_4547_17658# 0.00431f
C142 a_4547_19242# a_4547_18978# 0.28316f
C143 a_4462_21565# a_4548_21565# 0.02797f
C144 a_4548_21871# a_12731_21863# 0.01155f
C145 a_4461_18186# VDPWR 0.0082f
C146 a_13554_19156# a_4548_20340# 0.0048f
C147 a_4461_19770# a_4547_18450# 0.26585f
C148 a_5691_14643# a_4547_18978# 0.00431f
C149 a_4548_21258# VDPWR 0.10885f
C150 uo_out[0] uio_in[7] 0.007f
C151 ua[1] a_12277_16894# 0.00253f
C152 a_5691_14086# a_12731_21863# 0.01705f
C153 a_5691_14643# a_12278_21258# 0.00583f
C154 a_4461_19770# a_4548_20952# 0.04493f
C155 a_4461_19242# a_4547_19506# 0.01946f
C156 w_15070_13306# VDPWR 0.29949f
C157 uo_out[4] uo_out[3] 0.007f
C158 a_4547_19506# VDPWR 0.00754f
C159 ua[1] a_4547_18714# 0.00111f
C160 a_4461_19770# w_4261_13061# 0.04233f
C161 a_13554_19156# a_17330_18472# 0.52839f
C162 a_5691_14643# a_15380_18436# 2.44101f
C163 a_4547_19770# a_4547_19506# 0.28316f
C164 a_5691_14086# a_16457_19785# 0.77777f
C165 a_4461_19770# a_4547_19242# 0.34937f
C166 ua[2] VDPWR 53.2137f
C167 ua[1] a_4462_20952# 0.00123f
C168 a_15380_18436# w_15070_19285# 0.08623f
C169 a_12277_19506# VDPWR 0.00222f
C170 uio_out[0] uo_out[7] 0.007f
C171 a_4547_19770# a_12277_19506# 0.01946f
C172 w_13200_19935# VDPWR 0.14006f
C173 a_12278_20034# a_5691_14086# 0
C174 a_4548_20034# a_13554_19156# 0
C175 a_4461_19770# a_5691_14643# 0.48943f
C176 a_4461_19242# ua[1] 0.01184f
C177 a_4547_17658# a_4547_16894# 0.28316f
C178 ua[1] VDPWR 6.49135f
C179 a_4547_19770# ua[1] 0
C180 a_12278_20646# a_4548_20646# 0.02797f
C181 uio_out[5] uio_out[4] 0.007f
C182 a_5691_14086# ua[0] 0.34802f
C183 ui_in[2] ui_in[1] 0.007f
C184 a_12731_21863# a_12278_20646# 0
C185 a_12278_21258# a_4548_21258# 0.02797f
C186 a_5691_14086# a_12277_17922# 0.01925f
C187 a_5691_14643# a_4547_17922# 0.00431f
C188 a_4461_19770# a_4547_16894# 2.06054f
C189 uio_oe[1] uio_oe[0] 0.007f
C190 ui_in[6] ui_in[5] 0.007f
C191 a_4547_18714# VDPWR 0.0075f
C192 a_13554_19156# a_4548_20646# 0.00287f
C193 a_4461_19770# a_4461_18186# 0.01076f
C194 uio_oe[5] uio_oe[4] 0.007f
C195 a_4462_20952# VDPWR 0.01323f
C196 uio_in[2] uio_in[1] 0.007f
C197 ua[1] a_4547_17658# 0.00452f
C198 a_13554_19156# a_12731_21863# 0.85191f
C199 a_12278_20034# a_12278_20646# 0.00868f
C200 a_12277_19506# a_12278_21258# 0
C201 a_4461_19770# a_4548_21258# 0.02918f
C202 a_15380_18436# w_15070_13306# 0.01456f
C203 w_13139_18869# a_12731_21863# 0
C204 w_20495_17056# VDPWR 0.12301f
C205 a_4461_19242# VDPWR 0.0082f
C206 ua[1] a_4547_18978# 0.00111f
C207 a_5691_14643# a_17330_18472# 0.6691f
C208 a_4461_19770# a_4547_19506# 0.46335f
C209 a_17330_18472# w_15070_19285# 0.12191f
C210 a_15380_18436# w_13200_19935# 0
C211 a_4547_19770# VDPWR 0
C212 a_4461_19770# ua[2] 0.13345f
C213 a_4461_19770# a_12277_19506# 0.03573f
C214 a_4548_20034# a_5691_14643# 0.03367f
C215 a_12278_20034# a_13554_19156# 0.00117f
C216 a_4547_17658# a_12277_16894# 0.01946f
C217 a_4461_19770# ua[1] 2.16811f
C218 a_4547_18186# a_12277_17922# 0.01946f
C219 a_12731_21863# m3_13650_20824# 0.07046f
C220 a_4547_18978# a_4547_18714# 0.28316f
C221 a_4461_18714# a_4461_18186# 0.00871f
C222 a_4548_20952# a_4548_20646# 0.28316f
C223 a_13554_19156# ua[0] 0.04001f
C224 a_4548_21565# a_4548_21258# 0.2814f
C225 a_4547_17658# VDPWR 0.0075f
C226 a_13554_19156# a_12277_17922# 0.00255f
C227 a_4461_19770# a_12277_16894# 0.03816f
C228 a_4462_21565# a_4548_21871# 0.02797f
C229 a_4547_18978# VDPWR 0.00754f
C230 a_5691_14643# a_4548_20646# 0.01101f
C231 a_4461_19770# a_4547_18714# 0.27748f
C232 a_12278_21258# VDPWR 0.00357f
C233 uo_out[1] uo_out[0] 0.007f
C234 ua[1] a_4547_17922# 0.00111f
C235 a_5691_14643# a_12731_21863# 0.32331f
C236 a_17330_18472# w_15070_13306# 0.01939f
C237 a_5691_14086# a_12277_18978# 0.01872f
C238 w_15070_19285# a_12731_21863# 0.00198f
C239 ua[1] a_4548_20340# 0
C240 uo_out[5] uo_out[4] 0.007f
C241 a_15380_18436# VDPWR 5.53382f
C242 a_17330_18472# ua[2] 12.3455f
C243 ua[1] a_4461_18714# 0.01158f
C244 a_13554_19156# a_5691_14086# 0.55091f
C245 a_4461_19770# a_4461_19242# 0.02695f
C246 a_5691_14643# a_16457_19785# 1.14873f
C247 ua[1] a_4548_21565# 0
C248 uio_out[1] uio_out[0] 0.007f
C249 a_5691_14086# w_13139_18869# 0.0227f
C250 a_16457_19785# w_15070_19285# 0.05243f
C251 a_4461_19770# VDPWR 0.4268f
C252 a_4548_20034# a_12277_19506# 0
C253 a_4461_19770# a_4547_19770# 0.57323f
C254 a_12278_20034# a_5691_14643# 0.01526f
C255 a_17330_18472# ua[1] 1.24692f
C256 a_4548_20034# ua[1] 0.06919f
C257 a_4461_18186# a_4461_17658# 0.00868f
C258 a_4461_18714# a_4547_18714# 0.01947f
C259 a_5691_14086# m3_13650_20824# 0.00884f
C260 uio_out[6] uio_out[5] 0.007f
C261 a_5691_14643# ua[0] 0
C262 ui_in[3] ui_in[2] 0.007f
C263 a_4547_17922# VDPWR 0.0075f
C264 w_15070_19285# ua[0] 0.00857f
C265 a_13554_19156# a_4547_18186# 0
C266 a_5691_14643# a_12277_17922# 0.00423f
C267 a_4461_19242# a_4461_18714# 0.00871f
C268 a_5691_14086# a_4547_18450# 0.03934f
C269 a_4461_19770# a_4547_17658# 0.28328f
C270 uio_oe[2] uio_oe[1] 0.007f
C271 a_4548_20340# VDPWR 0.01249f
C272 ui_in[7] ui_in[6] 0.007f
C273 a_4461_18714# VDPWR 0.0082f
C274 a_13554_19156# a_12278_20646# 0.00218f
C275 a_4461_19770# a_4547_18978# 0.3003f
C276 uio_oe[6] uio_oe[5] 0.007f
C277 a_4548_21565# VDPWR 0.1303f
C278 uio_in[3] uio_in[2] 0.007f
C279 ua[1] a_4461_17658# 0.01153f
C280 a_16457_19785# w_15070_13306# 0.00264f
C281 a_5691_14086# w_4261_13061# 0.01864f
C282 a_17330_18472# w_20495_17056# 0.01565f
C283 a_13554_19156# a_12277_18978# 0.00172f
C284 ua[1] a_4548_20646# 0
C285 w_13200_19935# a_12731_21863# 0.01837f
C286 a_17330_18472# VDPWR 9.2552f
C287 a_12277_18978# w_13139_18869# 0
C288 a_5691_14643# a_5691_14086# 5.19133f
C289 a_13554_19156# w_13139_18869# 0.04315f
C290 a_5691_14086# w_15070_19285# 0.06145f
C291 a_4548_20034# VDPWR 0.01247f
C292 a_4548_20034# a_4547_19770# 0.28312f
C293 a_12278_20034# a_12277_19506# 0.00861f
C294 a_16457_19785# ua[1] 0
C295 a_4547_17922# a_4547_17658# 0.28316f
C296 a_12278_20646# m3_13650_20824# 0
C297 a_4547_18450# a_4547_18186# 0.28316f
C298 ua[0] w_15070_13306# 0.06819f
C299 a_4461_18714# a_4547_18978# 0.01947f
C300 a_4548_20952# a_12278_20646# 0.02797f
C301 ua[0] ua[2] 4.68781f
C302 a_13554_19156# m3_13650_20824# 0.18012f
C303 a_4548_21565# a_12278_21258# 0.02797f
C304 a_4461_17658# VDPWR 0.0082f
C305 a_5691_14643# a_4547_18186# 0.00431f
C306 a_13554_19156# a_4547_18450# 0
C307 a_4461_19770# a_4547_17922# 0.27223f
C308 a_4548_20646# VDPWR 0.01249f
C309 uio_in[6] uio_in[5] 0.007f
C310 a_4461_19770# a_4548_20340# 0.14683f
C311 a_5691_14643# a_12278_20646# 0.00792f
C312 ua[1] ua[0] 2.05842f
C313 a_13554_19156# a_4548_20952# 0.00502f
C314 a_4547_19242# a_12277_18978# 0.01946f
C315 a_4461_19770# a_4461_18714# 0.01143f
C316 a_12731_21863# VDPWR 2.28869f
C317 uo_out[2] uo_out[1] 0.007f
C318 a_5691_14086# w_15070_13306# 0.03529f
C319 a_16457_19785# w_20495_17056# 0.01857f
C320 a_13554_19156# w_4261_13061# 0.01614f
C321 a_5691_14643# a_12277_18978# 0.01738f
C322 a_13554_19156# a_4547_19242# 0
C323 a_17330_18472# a_15380_18436# 1.81989f
C324 ua[1] a_4462_20340# 0.02034f
C325 uo_out[6] uo_out[5] 0.007f
C326 a_16457_19785# VDPWR 4.12363f
C327 a_5691_14086# ua[2] 3.14666f
C328 a_5691_14643# a_13554_19156# 0.84709f
C329 a_12277_19506# a_5691_14086# 0.00119f
C330 uio_out[2] uio_out[1] 0.007f
C331 a_5691_14643# w_13139_18869# 0.01462f
C332 a_5691_14086# w_13200_19935# 0.01046f
C333 a_13554_19156# w_15070_19285# 0.0058f
C334 a_4548_20034# a_4461_19770# 0.31907f
C335 ua[3] VGND 0.30014f
C336 ua[4] VGND 0.30014f
C337 ua[5] VGND 0.30014f
C338 ua[6] VGND 0.30014f
C339 ua[7] VGND 0.30014f
C340 ena VGND 0.05967f
C341 clk VGND 0.04104f
C342 rst_n VGND 0.04104f
C343 ui_in[0] VGND 0.04104f
C344 ui_in[1] VGND 0.04104f
C345 ui_in[2] VGND 0.04104f
C346 ui_in[3] VGND 0.04104f
C347 ui_in[4] VGND 0.04104f
C348 ui_in[5] VGND 0.04104f
C349 ui_in[6] VGND 0.04104f
C350 ui_in[7] VGND 0.04104f
C351 uio_in[0] VGND 0.04104f
C352 uio_in[1] VGND 0.04104f
C353 uio_in[2] VGND 0.04104f
C354 uio_in[3] VGND 0.04104f
C355 uio_in[4] VGND 0.04104f
C356 uio_in[5] VGND 0.04104f
C357 uio_in[6] VGND 0.04104f
C358 uio_in[7] VGND 0.04104f
C359 uo_out[0] VGND 0.04104f
C360 uo_out[1] VGND 0.04104f
C361 uo_out[2] VGND 0.04104f
C362 uo_out[3] VGND 0.04104f
C363 uo_out[4] VGND 0.04104f
C364 uo_out[5] VGND 0.04104f
C365 uo_out[6] VGND 0.04104f
C366 uo_out[7] VGND 0.04104f
C367 uio_out[0] VGND 0.04104f
C368 uio_out[1] VGND 0.04104f
C369 uio_out[2] VGND 0.04104f
C370 uio_out[3] VGND 0.04104f
C371 uio_out[4] VGND 0.04104f
C372 uio_out[5] VGND 0.04104f
C373 uio_out[6] VGND 0.04104f
C374 uio_out[7] VGND 0.04104f
C375 uio_oe[0] VGND 0.04104f
C376 uio_oe[1] VGND 0.04104f
C377 uio_oe[2] VGND 0.04104f
C378 uio_oe[3] VGND 0.04104f
C379 uio_oe[4] VGND 0.04104f
C380 uio_oe[5] VGND 0.04104f
C381 uio_oe[6] VGND 0.04104f
C382 uio_oe[7] VGND 0.05967f
C383 ua[1] VGND 42.7426f
C384 VDPWR VGND 0.12634p
C385 m3_13650_20824# VGND 0.05927f ; **FLOATING
C386 a_12277_16894# VGND 9.10734f
C387 a_4461_17658# VGND 4.06519f
C388 a_12277_17922# VGND 4.05678f
C389 a_4461_18186# VGND 4.04704f
C390 a_4461_18714# VGND 4.04559f
C391 a_12277_18978# VGND 4.03175f
C392 a_4461_19242# VGND 4.045f
C393 a_15380_18436# VGND 0.49121f
C394 a_16457_19785# VGND 14.82423f
C395 a_12277_19506# VGND 4.04577f
C396 a_12278_20034# VGND 4.79875f
C397 a_4462_20340# VGND 4.80647f
C398 a_12278_20646# VGND 4.79941f
C399 a_4462_20952# VGND 4.81151f
C400 a_12278_21258# VGND 4.83401f
C401 a_4462_21565# VGND 5.2285f
C402 w_4261_13061# VGND 0.21456f ; **FLOATING
C403 w_15070_13306# VGND 0.1031f ; **FLOATING
C404 w_20495_17056# VGND 0.02418f ; **FLOATING
C405 w_13139_18869# VGND 0.00742f ; **FLOATING
C406 w_15070_19285# VGND 0.123f ; **FLOATING
C407 w_13200_19935# VGND 0.03111f ; **FLOATING
C408 VGND.t3 VGND 0.98242f
C409 VGND.t16 VGND 4.78889f
C410 VGND.t23 VGND 13.52102f
C411 VGND.t34 VGND 6.76051f
C412 VGND.t1 VGND 2.63987f
C413 VGND.t59 VGND 6.63315f
C414 VGND.t52 VGND 15.6884f
C415 VGND.t49 VGND 0.94947f
C416 VGND.t14 VGND 0.08727f
C417 VGND.t12 VGND 8.49319f
C418 VGND.t4 VGND 6.46505f
C419 VGND.t43 VGND 0.60575f
C420 VDPWR.n0 VGND 0.17403f
C421 VDPWR.n1 VGND 0.8446f
C422 VDPWR.n2 VGND 0.25636f
C423 VDPWR.n3 VGND 0.34001f
C424 VDPWR.n4 VGND 1.23995f
C425 VDPWR.n5 VGND 0.34087f
C426 VDPWR.n6 VGND 0.28871f
C427 VDPWR.n7 VGND 0.67318f
C428 VDPWR.n8 VGND 0.04874f
C429 VDPWR.n9 VGND 0.04161f
C430 VDPWR.n10 VGND 0.02218f
C431 VDPWR.n11 VGND 0.34203f
C432 VDPWR.n12 VGND 0.19485f
C433 VDPWR.n13 VGND 0.14718f
C434 VDPWR.n14 VGND 0.36285f
C435 VDPWR.n15 VGND 0.19485f
C436 VDPWR.n16 VGND 0.34203f
C437 VDPWR.n17 VGND 0.32121f
C438 VDPWR.n18 VGND 0.07236f
C439 VDPWR.n19 VGND 0.04161f
C440 VDPWR.n20 VGND 0.02816f
C441 VDPWR.n21 VGND 0.19485f
C442 VDPWR.n22 VGND 0.14718f
C443 VDPWR.n23 VGND 0.36285f
C444 VDPWR.n24 VGND 0.19485f
C445 VDPWR.n25 VGND 0.34203f
C446 VDPWR.n26 VGND 0.32121f
C447 VDPWR.n27 VGND 0.07222f
C448 VDPWR.n28 VGND 0.0353f
C449 VDPWR.n29 VGND 0.04327f
C450 VDPWR.n30 VGND 0.02477f
C451 VDPWR.n31 VGND 0.19485f
C452 VDPWR.n32 VGND 0.14718f
C453 VDPWR.n33 VGND 0.36285f
C454 VDPWR.n34 VGND 0.04476f
C455 VDPWR.n35 VGND 0.04449f
C456 VDPWR.n36 VGND 0.04476f
C457 VDPWR.n37 VGND 0.14718f
C458 VDPWR.n38 VGND 0.14718f
C459 VDPWR.n39 VGND 0.04476f
C460 VDPWR.n40 VGND 0.14718f
C461 VDPWR.n41 VGND 0.04476f
C462 VDPWR.n42 VGND 0.14718f
C463 VDPWR.n43 VGND 0.04476f
C464 VDPWR.n44 VGND 0.14718f
C465 VDPWR.n45 VGND 0.04476f
C466 VDPWR.n46 VGND 0.14718f
C467 VDPWR.n47 VGND 0.04476f
C468 VDPWR.n48 VGND 0.14718f
C469 VDPWR.n49 VGND 0.04652f
C470 VDPWR.n50 VGND 0.043f
C471 VDPWR.n51 VGND 0.043f
C472 VDPWR.n52 VGND 0.04652f
C473 VDPWR.n53 VGND 0.04476f
C474 VDPWR.n54 VGND 0.14718f
C475 VDPWR.n55 VGND 0.04476f
C476 VDPWR.n56 VGND 0.14718f
C477 VDPWR.n57 VGND 0.04476f
C478 VDPWR.n58 VGND 0.14718f
C479 VDPWR.n59 VGND 0.04476f
C480 VDPWR.n60 VGND 0.14718f
C481 VDPWR.n61 VGND 0.04476f
C482 VDPWR.n62 VGND 0.14718f
C483 VDPWR.n63 VGND 0.04652f
C484 VDPWR.n64 VGND 0.043f
C485 VDPWR.n65 VGND 0.043f
C486 VDPWR.n66 VGND 0.04652f
C487 VDPWR.n67 VGND 0.04476f
C488 VDPWR.n68 VGND 0.14718f
C489 VDPWR.n69 VGND 0.04476f
C490 VDPWR.n70 VGND 0.14718f
C491 VDPWR.n71 VGND 0.04476f
C492 VDPWR.n72 VGND 0.14718f
C493 VDPWR.n73 VGND 0.04476f
C494 VDPWR.n74 VGND 0.14718f
C495 VDPWR.n75 VGND 0.04652f
C496 VDPWR.n76 VGND 0.043f
C497 VDPWR.n77 VGND 0.043f
C498 VDPWR.n78 VGND 0.04652f
C499 VDPWR.n79 VGND 0.1475f
C500 VDPWR.n80 VGND 0.36051f
C501 VDPWR.n81 VGND 0.34102f
C502 VDPWR.n82 VGND 0.04301f
C503 VDPWR.n83 VGND 0.04449f
C504 VDPWR.n84 VGND 0.34001f
C505 VDPWR.n85 VGND 0.34001f
C506 VDPWR.n86 VGND 0.34001f
C507 VDPWR.n87 VGND 0.04301f
C508 VDPWR.n88 VGND 0.04449f
C509 VDPWR.n89 VGND 0.34001f
C510 VDPWR.n90 VGND 0.34001f
C511 VDPWR.n91 VGND 0.34001f
C512 VDPWR.n92 VGND 0.04301f
C513 VDPWR.n93 VGND 0.04449f
C514 VDPWR.n94 VGND 0.34001f
C515 VDPWR.n95 VGND 0.34001f
C516 VDPWR.n96 VGND 0.34001f
C517 VDPWR.n97 VGND 0.04301f
C518 VDPWR.n98 VGND 0.04449f
C519 VDPWR.n99 VGND 0.34001f
C520 VDPWR.n100 VGND 0.34001f
C521 VDPWR.n101 VGND 0.34001f
C522 VDPWR.n102 VGND 0.04301f
C523 VDPWR.n103 VGND 0.04449f
C524 VDPWR.n104 VGND 0.34001f
C525 VDPWR.n105 VGND 0.34001f
C526 VDPWR.n106 VGND 0.34001f
C527 VDPWR.n107 VGND 0.04301f
C528 VDPWR.n108 VGND 0.04449f
C529 VDPWR.n109 VGND 0.34001f
C530 VDPWR.n110 VGND 0.34001f
C531 VDPWR.n111 VGND 0.34001f
C532 VDPWR.n112 VGND 0.04301f
C533 VDPWR.n113 VGND 0.04449f
C534 VDPWR.n114 VGND 0.34001f
C535 VDPWR.n115 VGND 0.34001f
C536 VDPWR.n116 VGND 0.34001f
C537 VDPWR.n117 VGND 0.04301f
C538 VDPWR.n118 VGND 0.04449f
C539 VDPWR.n119 VGND 0.34001f
C540 VDPWR.n120 VGND 0.34001f
C541 VDPWR.n121 VGND 0.34001f
C542 VDPWR.n122 VGND 0.04301f
C543 VDPWR.n123 VGND 0.04449f
C544 VDPWR.n124 VGND 0.34001f
C545 VDPWR.n125 VGND 0.34001f
C546 VDPWR.n126 VGND 0.34001f
C547 VDPWR.n127 VGND 0.04301f
C548 VDPWR.n128 VGND 0.04449f
C549 VDPWR.n129 VGND 0.34001f
C550 VDPWR.n130 VGND 0.34001f
C551 VDPWR.n131 VGND 0.34001f
C552 VDPWR.n132 VGND 0.04301f
C553 VDPWR.n133 VGND 0.04449f
C554 VDPWR.n134 VGND 0.34001f
C555 VDPWR.n135 VGND 0.34001f
C556 VDPWR.n136 VGND 0.34102f
C557 VDPWR.n137 VGND 0.04301f
C558 VDPWR.n138 VGND 0.04463f
C559 VDPWR.n139 VGND 0.33901f
C560 VDPWR.n140 VGND 0.34001f
C561 VDPWR.n141 VGND 0.34001f
C562 VDPWR.n142 VGND 0.04288f
C563 VDPWR.n143 VGND 0.04449f
C564 VDPWR.n144 VGND 0.34001f
C565 VDPWR.n145 VGND 0.34001f
C566 VDPWR.n146 VGND 0.34001f
C567 VDPWR.n147 VGND 0.04301f
C568 VDPWR.n148 VGND 0.04449f
C569 VDPWR.n149 VGND 0.34001f
C570 VDPWR.n150 VGND 0.34001f
C571 VDPWR.n151 VGND 0.34001f
C572 VDPWR.n152 VGND 0.04301f
C573 VDPWR.n153 VGND 0.04449f
C574 VDPWR.n154 VGND 0.34001f
C575 VDPWR.n155 VGND 0.34001f
C576 VDPWR.n156 VGND 0.34001f
C577 VDPWR.n157 VGND 0.04301f
C578 VDPWR.n158 VGND 0.04449f
C579 VDPWR.n159 VGND 0.34001f
C580 VDPWR.n160 VGND 0.34001f
C581 VDPWR.n161 VGND 0.34001f
C582 VDPWR.n162 VGND 0.04301f
C583 VDPWR.n163 VGND 0.04449f
C584 VDPWR.n164 VGND 0.34001f
C585 VDPWR.n165 VGND 0.34001f
C586 VDPWR.n166 VGND 0.34001f
C587 VDPWR.n167 VGND 0.04301f
C588 VDPWR.n168 VGND 0.04449f
C589 VDPWR.n169 VGND 0.34001f
C590 VDPWR.n170 VGND 0.34001f
C591 VDPWR.n171 VGND 0.04301f
C592 VDPWR.n172 VGND 10.2409f
C593 VDPWR.n173 VGND 0.02351f
C594 VDPWR.n174 VGND 0.19485f
C595 VDPWR.n175 VGND 0.04327f
C596 VDPWR.n176 VGND 0.19485f
C597 VDPWR.n177 VGND 0.03883f
C598 VDPWR.n178 VGND 0.19485f
C599 VDPWR.n179 VGND 0.19485f
C600 VDPWR.n180 VGND 0.19485f
C601 VDPWR.n181 VGND 0.19485f
C602 VDPWR.n182 VGND 0.19485f
C603 VDPWR.n183 VGND 0.19485f
C604 VDPWR.n184 VGND 0.19485f
C605 VDPWR.n185 VGND 0.19485f
C606 VDPWR.n186 VGND 0.19485f
C607 VDPWR.n187 VGND 0.19485f
C608 VDPWR.n188 VGND 0.19485f
C609 VDPWR.n189 VGND 0.17403f
C610 VDPWR.n190 VGND 0.66162f
C611 VDPWR.t28 VGND 0.02514f
C612 VDPWR.n191 VGND 0.00657f
C613 VDPWR.n192 VGND 0.01136f
C614 VDPWR.n194 VGND 0.01137f
C615 VDPWR.n196 VGND 0.17905f
C616 VDPWR.n202 VGND 0.07448f
C617 VDPWR.n220 VGND 0.00335f
C618 VDPWR.n225 VGND 0.07407f
C619 VDPWR.n232 VGND 0.00972f
C620 VDPWR.n233 VGND 0.01516f
C621 VDPWR.n234 VGND 0.26764f
C622 VDPWR.n235 VGND 0.26764f
C623 VDPWR.n236 VGND 0.17966f
C624 VDPWR.n238 VGND 0.01706f
C625 VDPWR.t5 VGND 0.2695f
C626 VDPWR.n240 VGND 0.01137f
C627 VDPWR.n241 VGND 0.17966f
C628 VDPWR.n243 VGND 0.01137f
C629 VDPWR.n244 VGND 0.17966f
C630 VDPWR.n246 VGND 0.01137f
C631 VDPWR.n247 VGND 0.17966f
C632 VDPWR.n249 VGND 0.01137f
C633 VDPWR.n250 VGND 0.17966f
C634 VDPWR.n252 VGND 0.01706f
C635 VDPWR.n253 VGND 0.2695f
C636 VDPWR.n255 VGND 0.01706f
C637 VDPWR.n256 VGND 0.01137f
C638 VDPWR.n257 VGND 0.22427f
C639 VDPWR.n258 VGND 0.01137f
C640 VDPWR.t11 VGND 0.44916f
C641 VDPWR.n262 VGND 0.01706f
C642 VDPWR.n263 VGND 0.01326f
C643 VDPWR.n264 VGND 0.01518f
C644 VDPWR.n265 VGND 0.01515f
C645 VDPWR.n266 VGND 0.01516f
C646 VDPWR.n267 VGND 0.01328f
C647 VDPWR.n268 VGND 0.01137f
C648 VDPWR.n269 VGND 0.01137f
C649 VDPWR.n270 VGND 0.01327f
C650 VDPWR.n271 VGND 0.01326f
C651 VDPWR.n272 VGND 0.01518f
C652 VDPWR.n273 VGND 0.01137f
C653 VDPWR.n275 VGND 0.01706f
C654 VDPWR.n277 VGND 0.26764f
C655 VDPWR.n278 VGND 0.01137f
C656 VDPWR.n279 VGND 0.30109f
C657 VDPWR.n281 VGND 0.03971f
C658 VDPWR.n282 VGND 0.1809f
C659 VDPWR.n283 VGND 0.27135f
C660 VDPWR.n284 VGND 0.00977f
C661 VDPWR.n286 VGND 0.00423f
C662 VDPWR.n287 VGND 0.01153f
C663 VDPWR.n289 VGND 0.01866f
C664 VDPWR.n290 VGND 0.02125f
C665 VDPWR.n291 VGND 0.00615f
C666 VDPWR.n292 VGND 0.00615f
C667 VDPWR.n293 VGND 0.00615f
C668 VDPWR.n294 VGND 0.00615f
C669 VDPWR.n295 VGND 0.00615f
C670 VDPWR.n296 VGND 0.00652f
C671 VDPWR.n297 VGND 0.00652f
C672 VDPWR.n298 VGND 0.00652f
C673 VDPWR.n299 VGND 0.0154f
C674 VDPWR.n300 VGND 0.00652f
C675 VDPWR.t25 VGND 0.01492f
C676 VDPWR.n301 VGND 0.021f
C677 VDPWR.n302 VGND 0.01181f
C678 VDPWR.n303 VGND 0.00715f
C679 VDPWR.n304 VGND 0.00715f
C680 VDPWR.n305 VGND 0.00715f
C681 VDPWR.n306 VGND 0.00706f
C682 VDPWR.n307 VGND 0.00652f
C683 VDPWR.n308 VGND 0.00652f
C684 VDPWR.n309 VGND 0.02167f
C685 VDPWR.n310 VGND 0.00652f
C686 VDPWR.t4 VGND 0.01399f
C687 VDPWR.n311 VGND 0.016f
C688 VDPWR.n312 VGND 0.01637f
C689 VDPWR.n313 VGND 0.00715f
C690 VDPWR.n314 VGND 0.00715f
C691 VDPWR.n315 VGND 0.00113f
C692 VDPWR.n316 VGND 0.00706f
C693 VDPWR.n317 VGND 0.01254f
C694 VDPWR.n318 VGND 0.01303f
C695 VDPWR.n319 VGND 0.0156f
C696 VDPWR.n320 VGND 0.00652f
C697 VDPWR.t7 VGND 0.01399f
C698 VDPWR.n321 VGND 0.01142f
C699 VDPWR.n322 VGND 0.01135f
C700 VDPWR.n323 VGND 0.0156f
C701 VDPWR.n324 VGND 0.05401f
C702 VDPWR.n325 VGND 0.00977f
C703 VDPWR.n327 VGND 0.17223f
C704 VDPWR.n328 VGND 1.09719f
C705 VDPWR.t3 VGND 0.1809f
C706 VDPWR.n329 VGND 0.1809f
C707 VDPWR.n330 VGND 0.10947f
C708 VDPWR.n331 VGND 0.04674f
C709 VDPWR.n332 VGND 0.01518f
C710 VDPWR.n333 VGND 0.04154f
C711 VDPWR.n334 VGND 0.01706f
C712 VDPWR.t8 VGND 0.44606f
C713 VDPWR.n337 VGND 0.01706f
C714 VDPWR.n339 VGND 0.01706f
C715 VDPWR.n340 VGND 0.0114f
C716 VDPWR.n341 VGND 0.01502f
C717 VDPWR.t26 VGND 23.00308f
C718 VDPWR.t6 VGND 0.02552f
C719 VDPWR.t9 VGND 0.0231f
C720 VDPWR.n342 VGND 0.09858f
C721 VDPWR.t20 VGND 0.09097f
C722 VDPWR.t12 VGND 16.13748f
C723 VDPWR.n343 VGND 0.09918f
C724 VDPWR.n344 VGND 0.07344f
C725 VDPWR.n356 VGND 0.07335f
C726 VDPWR.n357 VGND 0
C727 VDPWR.n358 VGND 0.06402f
C728 VDPWR.n359 VGND 0.01392f
C729 VDPWR.n360 VGND 0.55634f
C730 VDPWR.n361 VGND 0.02275f
C731 VDPWR.n362 VGND 0.22489f
C732 VDPWR.n364 VGND 0.01516f
C733 VDPWR.t17 VGND 0.35933f
C734 VDPWR.n365 VGND 0.2695f
C735 VDPWR.n367 VGND 0.01516f
C736 VDPWR.n368 VGND 0.2695f
C737 VDPWR.t16 VGND 0.2695f
C738 VDPWR.n370 VGND 0.01328f
C739 VDPWR.n371 VGND 0.17966f
C740 VDPWR.n373 VGND 0.09855f
C741 VDPWR.t15 VGND 0.0231f
C742 VDPWR.t22 VGND 0.02552f
C743 VDPWR.t30 VGND 0.02514f
C744 VDPWR.n374 VGND 0.01115f
C745 VDPWR.n375 VGND 0.17966f
C746 VDPWR.n377 VGND 0.01137f
C747 VDPWR.t14 VGND 0.17966f
C748 VDPWR.n379 VGND 0.01137f
C749 VDPWR.n380 VGND 0.2695f
C750 VDPWR.n382 VGND 0.01516f
C751 VDPWR.n383 VGND 0.2695f
C752 VDPWR.t13 VGND 0.2695f
C753 VDPWR.n385 VGND 0.00946f
C754 VDPWR.n386 VGND 0.01328f
C755 VDPWR.n387 VGND 0.17966f
C756 VDPWR.n389 VGND 0.01137f
C757 VDPWR.n390 VGND 0.17966f
C758 VDPWR.n392 VGND 0.01706f
C759 VDPWR.n393 VGND 0.01326f
C760 VDPWR.n394 VGND 0.01518f
C761 VDPWR.n395 VGND 0.01137f
C762 VDPWR.n396 VGND 0.17966f
C763 VDPWR.n398 VGND 0.01706f
C764 VDPWR.n400 VGND 0.01706f
C765 VDPWR.n401 VGND 0.01515f
C766 VDPWR.n402 VGND 0.01327f
C767 VDPWR.n403 VGND 0.01137f
C768 VDPWR.n404 VGND 0.17966f
C769 VDPWR.n406 VGND 0.01137f
C770 VDPWR.n407 VGND 0.17966f
C771 VDPWR.n409 VGND 0.01137f
C772 VDPWR.n410 VGND 0.01137f
C773 VDPWR.n411 VGND 0.01137f
C774 VDPWR.n412 VGND 0.01137f
C775 VDPWR.n413 VGND 0.17966f
C776 VDPWR.n415 VGND 0.01137f
C777 VDPWR.n416 VGND 0.17966f
C778 VDPWR.n418 VGND 0.01137f
C779 VDPWR.n419 VGND 0.01137f
C780 VDPWR.n420 VGND 0.00686f
C781 VDPWR.n421 VGND 0.01137f
C782 VDPWR.n422 VGND 0.17966f
C783 VDPWR.n424 VGND 0.01137f
C784 VDPWR.n425 VGND 0.00865f
C785 VDPWR.n426 VGND 0.01137f
C786 VDPWR.n427 VGND 0.01137f
C787 VDPWR.n428 VGND 0.17966f
C788 VDPWR.n430 VGND 0.01137f
C789 VDPWR.n431 VGND 0.17966f
C790 VDPWR.n433 VGND 0.01706f
C791 VDPWR.n434 VGND 0.01326f
C792 VDPWR.n435 VGND 0.01518f
C793 VDPWR.n436 VGND 0.01137f
C794 VDPWR.n437 VGND 0.17966f
C795 VDPWR.n439 VGND 0.01706f
C796 VDPWR.n441 VGND 0.01706f
C797 VDPWR.n442 VGND 0.01515f
C798 VDPWR.n443 VGND 0.01518f
C799 VDPWR.n444 VGND 0.01137f
C800 VDPWR.n445 VGND 0.17966f
C801 VDPWR.n447 VGND 0.01706f
C802 VDPWR.n449 VGND 0.01706f
C803 VDPWR.n450 VGND 0.01515f
C804 VDPWR.n451 VGND 0.01908f
C805 VDPWR.n453 VGND 0.00617f
C806 VDPWR.n454 VGND 0.00617f
C807 VDPWR.n455 VGND 0.012f
C808 VDPWR.n456 VGND 0.00717f
C809 VDPWR.n457 VGND 0.00717f
C810 VDPWR.n458 VGND 0.01643f
C811 VDPWR.n459 VGND 0.00717f
C812 VDPWR.n460 VGND 0.01179f
C813 VDPWR.n461 VGND 0.00708f
C814 VDPWR.n462 VGND 0.00117f
C815 VDPWR.n463 VGND 0.00654f
C816 VDPWR.n464 VGND 0.01587f
C817 VDPWR.n465 VGND 0.01284f
C818 VDPWR.n466 VGND 0.01277f
C819 VDPWR.t18 VGND 0.01399f
C820 VDPWR.n467 VGND 0.0157f
C821 VDPWR.n468 VGND 0.00717f
C822 VDPWR.n469 VGND 0.00708f
C823 VDPWR.n470 VGND 0.00654f
C824 VDPWR.n471 VGND 0.01598f
C825 VDPWR.n472 VGND 0.02163f
C826 VDPWR.n473 VGND 0.00654f
C827 VDPWR.t24 VGND 0.01399f
C828 VDPWR.n474 VGND 0.00654f
C829 VDPWR.n475 VGND 0.00717f
C830 VDPWR.n476 VGND 0.00617f
C831 VDPWR.n477 VGND 0.00617f
C832 VDPWR.n478 VGND 0.00617f
C833 VDPWR.n479 VGND 0.02102f
C834 VDPWR.n480 VGND 0.00654f
C835 VDPWR.n481 VGND 0.00654f
C836 VDPWR.n482 VGND 0.00654f
C837 VDPWR.n483 VGND 0.00654f
C838 VDPWR.t32 VGND 0.01492f
C839 VDPWR.n484 VGND 0.02025f
C840 VDPWR.n485 VGND 0.0164f
C841 VDPWR.n486 VGND 0.17685f
C842 VDPWR.n487 VGND 0.0098f
C843 VDPWR.n488 VGND 0.01108f
C844 VDPWR.n489 VGND 0.00919f
C845 VDPWR.n490 VGND 0.01327f
C846 VDPWR.n491 VGND 0.01137f
C847 VDPWR.n493 VGND 0.1809f
C848 VDPWR.n495 VGND 0.70099f
C849 VDPWR.n497 VGND 0.17966f
C850 VDPWR.n499 VGND 0.01137f
C851 VDPWR.n500 VGND 0.00578f
C852 VDPWR.n501 VGND 2.68019f
C853 VDPWR.n502 VGND 1.22519f
C854 VDPWR.n503 VGND 0.07351f
C855 VDPWR.n504 VGND 0.04327f
C856 VDPWR.t34 VGND 0.03717f
C857 VDPWR.n505 VGND 0.0562f
C858 VDPWR.n506 VGND 0.04327f
C859 VDPWR.n507 VGND 0.02427f
C860 VDPWR.n508 VGND 0.0053f
C861 VDPWR.n509 VGND 0.04415f
C862 VDPWR.n510 VGND 0.05718f
C863 VDPWR.n511 VGND 0.00184f
C864 VDPWR.n512 VGND 0.00517f
C865 VDPWR.t36 VGND 2.41111f
C866 VDPWR.n513 VGND 0.04654f
C867 VDPWR.n514 VGND 0.01808f
C868 VDPWR.n515 VGND 0.0018f
C869 VDPWR.n516 VGND 0.00531f
C870 VDPWR.t35 VGND 0.43261f
C871 VDPWR.n517 VGND 0.03793f
C872 VDPWR.n518 VGND 0.04364f
C873 VDPWR.n519 VGND 0.00887f
C874 VDPWR.n520 VGND 0.00251f
C875 VDPWR.t37 VGND 0.04463f
C876 VDPWR.n521 VGND 0.00333f
C877 VDPWR.n522 VGND 0.01017f
C878 VDPWR.n523 VGND 0.01201f
C879 VDPWR.n524 VGND 0.0034f
C880 VDPWR.n525 VGND 0.02501f
C881 VDPWR.n526 VGND 0.02204f
C882 VDPWR.n527 VGND 0.02734f
C883 VDPWR.n528 VGND 0.00261f
C884 VDPWR.n529 VGND 0.06581f
C885 VDPWR.n530 VGND 0.08697f
C886 VDPWR.t2 VGND 3.17849f
C887 VDPWR.t1 VGND 0.88767f
C888 VDPWR.n531 VGND 0.00219f
C889 VDPWR.n532 VGND 0.00936f
C890 VDPWR.n533 VGND 0.04361f
C891 VDPWR.n534 VGND 0.05731f
C892 VDPWR.n535 VGND 0.04389f
C893 VDPWR.n536 VGND 0.00319f
C894 VDPWR.n537 VGND 0.02421f
C895 VDPWR.n538 VGND 0.0043f
C896 VDPWR.t33 VGND 1.93017f
C897 VDPWR.n539 VGND 0.0043f
C898 VDPWR.n540 VGND 0.0242f
C899 VDPWR.n541 VGND 0.07385f
C900 VDPWR.n542 VGND 0.04327f
C901 VDPWR.n543 VGND 0.03133f
C902 VDPWR.n544 VGND 0.04327f
C903 VDPWR.n545 VGND 0.04272f
C904 VDPWR.n546 VGND 0.01341f
C905 VDPWR.n547 VGND 0.01806f
C906 VDPWR.n548 VGND 0.04327f
C907 VDPWR.n549 VGND 0.0469f
C908 VDPWR.n550 VGND 0.00683f
C909 VDPWR.n551 VGND 0.02183f
C910 VDPWR.n552 VGND 0.00234f
C911 VDPWR.n553 VGND 0.00246f
C912 VDPWR.n554 VGND 0.00243f
C913 VDPWR.n555 VGND 0.00683f
C914 VDPWR.n556 VGND 0.00625f
C915 VDPWR.n557 VGND 0.00664f
C916 VDPWR.n558 VGND 0.00664f
C917 VDPWR.n559 VGND 0.00566f
C918 VDPWR.n560 VGND 0.00664f
C919 VDPWR.n561 VGND 0.00664f
C920 VDPWR.n562 VGND 0.0043f
C921 VDPWR.n563 VGND 0.00664f
C922 VDPWR.n564 VGND 0.00664f
C923 VDPWR.n565 VGND 0.00664f
C924 VDPWR.n566 VGND 0.01688f
C925 VDPWR.n567 VGND 0.00664f
C926 VDPWR.n568 VGND 0.00498f
C927 VDPWR.n569 VGND 0.00664f
C928 VDPWR.n570 VGND 0.00664f
C929 VDPWR.n571 VGND 0.00557f
C930 VDPWR.n572 VGND 0.00664f
C931 VDPWR.n573 VGND 0.00664f
C932 VDPWR.n574 VGND 0.00644f
C933 VDPWR.t66 VGND 0.2246f
C934 VDPWR.n575 VGND 0
C935 VDPWR.n576 VGND 0.00664f
C936 VDPWR.n577 VGND 0.00301f
C937 VDPWR.n578 VGND 0.01413f
C938 VDPWR.n579 VGND 0.00664f
C939 VDPWR.n580 VGND 0.00664f
C940 VDPWR.n581 VGND 0.00664f
C941 VDPWR.n582 VGND 0.00371f
C942 VDPWR.n583 VGND 0.00664f
C943 VDPWR.n584 VGND 0.00664f
C944 VDPWR.n585 VGND 0.00351f
C945 VDPWR.n586 VGND 0.00664f
C946 VDPWR.n587 VGND 0.00189f
C947 VDPWR.n588 VGND 0.00254f
C948 VDPWR.n589 VGND 0.00664f
C949 VDPWR.n590 VGND 0.00664f
C950 VDPWR.n591 VGND 0.00322f
C951 VDPWR.n592 VGND 0.01296f
C952 VDPWR.n593 VGND 0.0087f
C953 VDPWR.n594 VGND 0.00664f
C954 VDPWR.n595 VGND 0.00664f
C955 VDPWR.n596 VGND 0.00241f
C956 VDPWR.n597 VGND 0.00385f
C957 VDPWR.n598 VGND 0.05807f
C958 VDPWR.t62 VGND 0.22702f
C959 VDPWR.t70 VGND 0.22715f
C960 VDPWR.n599 VGND 0.04859f
C961 VDPWR.n600 VGND 0.00802f
C962 VDPWR.n601 VGND 0.00878f
C963 VDPWR.n602 VGND 0.00329f
C964 VDPWR.n603 VGND 0.00878f
C965 VDPWR.n604 VGND 0.00878f
C966 VDPWR.n605 VGND 0.00878f
C967 VDPWR.n606 VGND 0.00318f
C968 VDPWR.n607 VGND 0.00878f
C969 VDPWR.n608 VGND 0.01272f
C970 VDPWR.n609 VGND 0.00687f
C971 VDPWR.n610 VGND 0.01311f
C972 VDPWR.n611 VGND 0.00687f
C973 VDPWR.n612 VGND 0.013f
C974 VDPWR.n613 VGND 0.00687f
C975 VDPWR.n614 VGND 0.0135f
C976 VDPWR.n615 VGND 0.0255f
C977 VDPWR.n616 VGND 0.02054f
C978 VDPWR.n617 VGND 0.00188f
C979 VDPWR.t72 VGND 0.20815f
C980 VDPWR.n618 VGND 0.04978f
C981 VDPWR.n619 VGND 0.07735f
C982 VDPWR.n620 VGND 0.00226f
C983 VDPWR.n621 VGND 0.00398f
C984 VDPWR.n622 VGND 0.00172f
C985 VDPWR.t74 VGND 0.2061f
C986 VDPWR.n623 VGND 0.01946f
C987 VDPWR.n624 VGND 0.00821f
C988 VDPWR.n625 VGND 0.00811f
C989 VDPWR.n626 VGND 0.00305f
C990 VDPWR.n627 VGND 0.00716f
C991 VDPWR.n628 VGND 0.00878f
C992 VDPWR.n629 VGND 0.00878f
C993 VDPWR.n630 VGND 0.0041f
C994 VDPWR.n631 VGND 0.00468f
C995 VDPWR.n632 VGND 0.00878f
C996 VDPWR.n633 VGND 0
C997 VDPWR.n634 VGND 0.00169f
C998 VDPWR.n635 VGND 0.01298f
C999 VDPWR.n636 VGND 0.0387f
C1000 VDPWR.n637 VGND 0.04837f
C1001 VDPWR.n638 VGND 0.0949f
C1002 VDPWR.n639 VGND 0.18979f
C1003 VDPWR.n640 VGND 0.18979f
C1004 VDPWR.n641 VGND 0.18979f
C1005 VDPWR.n642 VGND 0.26909f
C1006 VDPWR.n643 VGND 0.18979f
C1007 VDPWR.n644 VGND 0.00652f
C1008 VDPWR.n646 VGND 0.03883f
C1009 VDPWR.n647 VGND 0.04324f
C1010 VDPWR.n648 VGND 0.00679f
C1011 VDPWR.t49 VGND 0.20539f
C1012 VDPWR.n649 VGND 0.18979f
C1013 VDPWR.n650 VGND 0.18979f
C1014 VDPWR.n651 VGND 0.28469f
C1015 VDPWR.n652 VGND 0.00723f
C1016 VDPWR.n653 VGND 0.00734f
C1017 VDPWR.n654 VGND 0.00734f
C1018 VDPWR.n655 VGND 0.00733f
C1019 VDPWR.n656 VGND 0.00733f
C1020 VDPWR.n657 VGND 0.00722f
C1021 VDPWR.n658 VGND 0.00733f
C1022 VDPWR.n659 VGND 0.00733f
C1023 VDPWR.n660 VGND 0.00733f
C1024 VDPWR.n661 VGND 0.00733f
C1025 VDPWR.n662 VGND 0.00723f
C1026 VDPWR.n663 VGND 0.00734f
C1027 VDPWR.n664 VGND 0.00871f
C1028 VDPWR.n666 VGND 0.00146f
C1029 VDPWR.n667 VGND 0.00744f
C1030 VDPWR.n668 VGND 0.00734f
C1031 VDPWR.n669 VGND 0.01484f
C1032 VDPWR.n670 VGND 0.00756f
C1033 VDPWR.n671 VGND 0.00747f
C1034 VDPWR.n672 VGND 0.00734f
C1035 VDPWR.n673 VGND 0.00743f
C1036 VDPWR.n674 VGND 0.00737f
C1037 VDPWR.n675 VGND 0.00734f
C1038 VDPWR.n685 VGND 0.68135f
C1039 VDPWR.n686 VGND 0.00593f
C1040 VDPWR.n687 VGND 0.00945f
C1041 VDPWR.n688 VGND 0.01009f
C1042 VDPWR.n689 VGND 0.0033f
C1043 VDPWR.n690 VGND 0.00535f
C1044 VDPWR.n691 VGND 0.00262f
C1045 VDPWR.n692 VGND 0.00797f
C1046 VDPWR.n693 VGND 0.00819f
C1047 VDPWR.n694 VGND 0.00808f
C1048 VDPWR.n695 VGND 0.00535f
C1049 VDPWR.n696 VGND 0.00797f
C1050 VDPWR.n697 VGND 0.00558f
C1051 VDPWR.n698 VGND 0.00819f
C1052 VDPWR.n699 VGND 0.00794f
C1053 VDPWR.n700 VGND 0.00794f
C1054 VDPWR.n701 VGND 0.00794f
C1055 VDPWR.n702 VGND 0.00794f
C1056 VDPWR.n703 VGND 0.00794f
C1057 VDPWR.n704 VGND 0.00794f
C1058 VDPWR.n705 VGND 0.00794f
C1059 VDPWR.n706 VGND 0.00772f
C1060 VDPWR.n707 VGND 0.07897f
C1061 VDPWR.n708 VGND 0.00772f
C1062 VDPWR.n709 VGND 0.00772f
C1063 VDPWR.n710 VGND 0.00794f
C1064 VDPWR.n711 VGND 0.00772f
C1065 VDPWR.n712 VGND 0.00772f
C1066 VDPWR.n713 VGND 0.00794f
C1067 VDPWR.n714 VGND 0.00772f
C1068 VDPWR.n715 VGND 0.00761f
C1069 VDPWR.n716 VGND 0.00794f
C1070 VDPWR.n717 VGND 0.00772f
C1071 VDPWR.n718 VGND 0.00772f
C1072 VDPWR.n719 VGND 0.00794f
C1073 VDPWR.n720 VGND 0.00761f
C1074 VDPWR.n721 VGND 0.00772f
C1075 VDPWR.n722 VGND 0.00794f
C1076 VDPWR.n723 VGND 0.00772f
C1077 VDPWR.n724 VGND 0.00772f
C1078 VDPWR.n725 VGND 0.00794f
C1079 VDPWR.n726 VGND 0.00353f
C1080 VDPWR.n727 VGND 0.00637f
C1081 VDPWR.n728 VGND 0.0025f
C1082 VDPWR.n729 VGND 0.00558f
C1083 VDPWR.n730 VGND 0.0074f
C1084 VDPWR.n731 VGND 0.00307f
C1085 VDPWR.t58 VGND 0.10719f
C1086 VDPWR.t56 VGND 0.10719f
C1087 VDPWR.t54 VGND 8.83794f
C1088 VDPWR.n732 VGND 0
C1089 VDPWR.n733 VGND 0.00687f
C1090 VDPWR.n734 VGND 0
C1091 VDPWR.n735 VGND 0.008f
C1092 VDPWR.n736 VGND 0.00797f
C1093 VDPWR.n737 VGND 0.01096f
C1094 VDPWR.n738 VGND 0.00593f
C1095 VDPWR.n739 VGND 0.00871f
C1096 VDPWR.n741 VGND 0.18979f
C1097 VDPWR.n742 VGND 0.15228f
C1098 VDPWR.n743 VGND 0.00761f
C1099 VDPWR.n744 VGND 0.00794f
C1100 VDPWR.n745 VGND 0.00772f
C1101 VDPWR.n746 VGND 0.00794f
C1102 VDPWR.n747 VGND 0.00772f
C1103 VDPWR.n748 VGND 0.00794f
C1104 VDPWR.n749 VGND 0.00772f
C1105 VDPWR.n750 VGND 0.00794f
C1106 VDPWR.n751 VGND 0.00772f
C1107 VDPWR.n752 VGND 0.00794f
C1108 VDPWR.n753 VGND 0.00761f
C1109 VDPWR.n754 VGND 0.00794f
C1110 VDPWR.n755 VGND 0.00772f
C1111 VDPWR.n756 VGND 0.00794f
C1112 VDPWR.n757 VGND 0.00772f
C1113 VDPWR.n758 VGND 0.00794f
C1114 VDPWR.n759 VGND 0.00772f
C1115 VDPWR.n760 VGND 0.00794f
C1116 VDPWR.n761 VGND 0.00772f
C1117 VDPWR.n762 VGND 0.00794f
C1118 VDPWR.n763 VGND 0.00761f
C1119 VDPWR.n764 VGND 0.00794f
C1120 VDPWR.n765 VGND 0.00772f
C1121 VDPWR.n766 VGND 0.00794f
C1122 VDPWR.n767 VGND 0.00804f
C1123 VDPWR.n768 VGND 0.00804f
C1124 VDPWR.n769 VGND 0.01569f
C1125 VDPWR.n770 VGND 0.00843f
C1126 VDPWR.n771 VGND 0.00843f
C1127 VDPWR.n772 VGND 0.00843f
C1128 VDPWR.n773 VGND 0.00843f
C1129 VDPWR.n774 VGND 0.00843f
C1130 VDPWR.n775 VGND 0.00843f
C1131 VDPWR.n776 VGND 0.00843f
C1132 VDPWR.n777 VGND 0.00843f
C1133 VDPWR.n778 VGND 0.00843f
C1134 VDPWR.n779 VGND 0.00843f
C1135 VDPWR.n780 VGND 0.00843f
C1136 VDPWR.n781 VGND 0.00843f
C1137 VDPWR.n782 VGND 0.00842f
C1138 VDPWR.n783 VGND 0.00853f
C1139 VDPWR.n784 VGND 0.00853f
C1140 VDPWR.n785 VGND 0.00851f
C1141 VDPWR.n786 VGND 0.00849f
C1142 VDPWR.n787 VGND 0.00851f
C1143 VDPWR.n788 VGND 0.00852f
C1144 VDPWR.n789 VGND 0.00853f
C1145 VDPWR.n790 VGND 0.01046f
C1146 VDPWR.n791 VGND 0.0104f
C1147 VDPWR.n792 VGND 0.04016f
C1148 VDPWR.t50 VGND 0.07021f
C1149 VDPWR.n793 VGND 0
C1150 VDPWR.n794 VGND 0.0249f
C1151 VDPWR.t47 VGND 0.10429f
C1152 VDPWR.n795 VGND 0.47718f
C1153 VDPWR.t44 VGND 0.10429f
C1154 VDPWR.n796 VGND 0.32846f
C1155 VDPWR.t41 VGND 0.10429f
C1156 VDPWR.n797 VGND 0.47718f
C1157 VDPWR.n798 VGND 0.02501f
C1158 VDPWR.n799 VGND 0.00804f
C1159 VDPWR.n800 VGND 0.00959f
C1160 VDPWR.n801 VGND 0.01198f
C1161 VDPWR.n802 VGND 0.04137f
C1162 VDPWR.n803 VGND 0.0077f
C1163 VDPWR.n804 VGND 0.00953f
C1164 VDPWR.n805 VGND 0.00804f
C1165 VDPWR.n806 VGND 0.00781f
C1166 VDPWR.n807 VGND 0.00781f
C1167 VDPWR.n808 VGND 0.00804f
C1168 VDPWR.n809 VGND 0.00781f
C1169 VDPWR.n810 VGND 0.00781f
C1170 VDPWR.n811 VGND 0.00804f
C1171 VDPWR.n812 VGND 0.00781f
C1172 VDPWR.n813 VGND 0.0077f
C1173 VDPWR.n814 VGND 0.00804f
C1174 VDPWR.n815 VGND 0.00772f
C1175 VDPWR.n816 VGND 0.00772f
C1176 VDPWR.n817 VGND 0.00794f
C1177 VDPWR.t39 VGND 0.07021f
C1178 VDPWR.n818 VGND 0.01234f
C1179 VDPWR.n819 VGND 0.00655f
C1180 VDPWR.n821 VGND 0.12547f
C1181 VDPWR.n822 VGND 0.01153f
C1182 VDPWR.n823 VGND 0.01153f
C1183 VDPWR.n824 VGND 0.01153f
C1184 VDPWR.n825 VGND 0.01726f
C1185 VDPWR.n826 VGND 0.01746f
C1186 VDPWR.n827 VGND 0.05175f
C1187 VDPWR.n828 VGND 0.03526f
C1188 VDPWR.n831 VGND 0.01169f
C1189 VDPWR.n832 VGND 0.03655f
C1190 VDPWR.n833 VGND 0.03488f
C1191 VDPWR.n836 VGND 0.01169f
C1192 VDPWR.n837 VGND 0.03791f
C1193 VDPWR.n838 VGND 0.03526f
C1194 VDPWR.n841 VGND 0.01169f
C1195 VDPWR.n842 VGND 0.03615f
C1196 VDPWR.n843 VGND 0.01753f
C1197 VDPWR.n844 VGND 0.00687f
C1198 VDPWR.n845 VGND 0.00687f
C1199 VDPWR.n846 VGND 0.01374f
C1200 VDPWR.n847 VGND 0.00372f
C1201 VDPWR.n848 VGND 0.0126f
C1202 VDPWR.n849 VGND 0.00687f
C1203 VDPWR.n850 VGND 0.00823f
C1204 VDPWR.n851 VGND 0.00659f
C1205 VDPWR.n852 VGND 0.03387f
C1206 VDPWR.n853 VGND 0.03488f
C1207 VDPWR.n860 VGND 0.29119f
C1208 VDPWR.n862 VGND 0.38479f
C1209 VDPWR.n864 VGND 0.57718f
C1210 VDPWR.t38 VGND 0.38479f
C1211 VDPWR.n867 VGND 0.38479f
C1212 VDPWR.n869 VGND 0.38479f
C1213 VDPWR.t40 VGND 0.38479f
C1214 VDPWR.n872 VGND 0.38479f
C1215 VDPWR.t42 VGND 0.99317f
C1216 VDPWR.n876 VGND 0.37699f
C1217 VDPWR.n878 VGND 0.37699f
C1218 VDPWR.t43 VGND 0.56548f
C1219 VDPWR.n881 VGND 0.56548f
C1220 VDPWR.t45 VGND 0.37959f
C1221 VDPWR.n884 VGND 0.38219f
C1222 VDPWR.n886 VGND 0.38219f
C1223 VDPWR.n888 VGND 0.38219f
C1224 VDPWR.t46 VGND 0.38219f
C1225 VDPWR.n891 VGND 0.38219f
C1226 VDPWR.n893 VGND 0.57328f
C1227 VDPWR.n896 VGND 0.38219f
C1228 VDPWR.t48 VGND 0.38219f
C1229 VDPWR.n899 VGND 0.0068f
C1230 VDPWR.n900 VGND 0.01165f
C1231 VDPWR.n901 VGND 0.00783f
C1232 VDPWR.n902 VGND 0.00615f
C1233 VDPWR.n903 VGND 0.04199f
C1234 VDPWR.n904 VGND 0.00754f
C1235 VDPWR.n905 VGND 0.0071f
C1236 VDPWR.n906 VGND 0.01169f
C1237 VDPWR.n907 VGND 0.0056f
C1238 VDPWR.n908 VGND 0.00776f
C1239 VDPWR.n909 VGND 0.00552f
C1240 VDPWR.n910 VGND 0.01169f
C1241 VDPWR.n911 VGND 0.00718f
C1242 VDPWR.n912 VGND 0.00776f
C1243 VDPWR.n913 VGND 0.0054f
C1244 VDPWR.n914 VGND 0.01169f
C1245 VDPWR.n915 VGND 0.00925f
C1246 VDPWR.n916 VGND 0.01347f
C1247 VDPWR.n917 VGND 0.01539f
C1248 VDPWR.n918 VGND 0.01346f
C1249 VDPWR.n919 VGND 0.01153f
C1250 VDPWR.n920 VGND 0.04547f
C1251 VDPWR.n921 VGND 0.05342f
C1252 VDPWR.n922 VGND 0.0396f
C1253 VDPWR.n923 VGND 0.01267f
C1254 VDPWR.n924 VGND 0.00428f
C1255 VDPWR.n925 VGND 0.31199f
C1256 VDPWR.n927 VGND 0.00945f
C1257 VDPWR.n928 VGND 0.0346f
C1258 VDPWR.n930 VGND 0.01129f
C1259 VDPWR.n931 VGND 0.04626f
C1260 VDPWR.n932 VGND 0.00713f
C1261 VDPWR.n933 VGND 0.00278f
C1262 VDPWR.n934 VGND 0.00317f
C1263 VDPWR.n935 VGND 0.00704f
C1264 VDPWR.n936 VGND 0.00314f
C1265 VDPWR.n937 VGND 0.0087f
C1266 VDPWR.n938 VGND 0.00843f
C1267 VDPWR.n939 VGND 0.00843f
C1268 VDPWR.n940 VGND 0.00843f
C1269 VDPWR.n941 VGND 0.00843f
C1270 VDPWR.n942 VGND 0.00843f
C1271 VDPWR.n943 VGND 0.00843f
C1272 VDPWR.n944 VGND 0.00843f
C1273 VDPWR.n945 VGND 0.00734f
C1274 VDPWR.n946 VGND 0.26159f
C1275 VDPWR.n947 VGND 0.08087f
C1276 VDPWR.n948 VGND 0.00734f
C1277 VDPWR.n949 VGND 0.00734f
C1278 VDPWR.n950 VGND 0.00843f
C1279 VDPWR.n951 VGND 0.00733f
C1280 VDPWR.n952 VGND 0.00734f
C1281 VDPWR.n953 VGND 0.00843f
C1282 VDPWR.n954 VGND 0.00733f
C1283 VDPWR.n955 VGND 0.00722f
C1284 VDPWR.n956 VGND 0.00843f
C1285 VDPWR.n957 VGND 0.00733f
C1286 VDPWR.n958 VGND 0.00733f
C1287 VDPWR.n959 VGND 0.00843f
C1288 VDPWR.n960 VGND 0.00722f
C1289 VDPWR.n961 VGND 0.00733f
C1290 VDPWR.n962 VGND 0.00843f
C1291 VDPWR.n963 VGND 0.00734f
C1292 VDPWR.n964 VGND 0.00734f
C1293 VDPWR.n965 VGND 0.00843f
C1294 VDPWR.n966 VGND 0.00734f
C1295 VDPWR.n967 VGND 0.00613f
C1296 VDPWR.n968 VGND 0.0076f
C1297 VDPWR.n969 VGND 0.00812f
C1298 VDPWR.n970 VGND 0.00515f
C1299 VDPWR.n971 VGND 0.00574f
C1300 VDPWR.n972 VGND 0.00765f
C1301 VDPWR.n973 VGND 0.00846f
C1302 VDPWR.t53 VGND 0.07028f
C1303 VDPWR.n974 VGND 0.0087f
C1304 VDPWR.n975 VGND 0.00315f
C1305 VDPWR.n976 VGND 0.00606f
C1306 VDPWR.n977 VGND 0.17074f
C1307 VDPWR.n978 VGND 0.33485f
C1308 VDPWR.n979 VGND 0.33485f
C1309 VDPWR.n980 VGND 0.33485f
C1310 VDPWR.n981 VGND 0.00546f
C1311 VDPWR.n982 VGND 0.00535f
C1312 VDPWR.n983 VGND 0.0074f
C1313 VDPWR.n984 VGND 0.00603f
C1314 VDPWR.n985 VGND 0.17074f
C1315 VDPWR.n986 VGND 0.00457f
C1316 VDPWR.n987 VGND 0.00772f
C1317 VDPWR.n988 VGND 0.00788f
C1318 VDPWR.t60 VGND 0.07028f
C1319 VDPWR.n989 VGND 0.04341f
C1320 VDPWR.n990 VGND 0.01129f
C1321 VDPWR.n992 VGND 0.0346f
C1322 VDPWR.n994 VGND 0.31199f
C1323 VDPWR.n995 VGND 0.23069f
C1324 VDPWR.n996 VGND 0.00671f
C1325 VDPWR.n997 VGND 0.05033f
C1326 VDPWR.n998 VGND 0.04751f
C1327 VDPWR.n999 VGND 0.00988f
C1328 VDPWR.n1000 VGND 0.01296f
C1329 VDPWR.n1001 VGND 0.01932f
C1330 VDPWR.n1002 VGND 0.00664f
C1331 VDPWR.n1003 VGND 0.00664f
C1332 VDPWR.n1004 VGND 0.00557f
C1333 VDPWR.n1005 VGND 0.00664f
C1334 VDPWR.n1006 VGND 0.00635f
C1335 VDPWR.n1007 VGND 0.00664f
C1336 VDPWR.n1008 VGND 0.00517f
C1337 VDPWR.n1009 VGND 0.00367f
C1338 VDPWR.n1010 VGND 0
C1339 VDPWR.n1011 VGND 0.04569f
C1340 VDPWR.n1012 VGND 0.12049f
C1341 VDPWR.n1013 VGND 0.01352f
C1342 VDPWR.n1014 VGND 0.0135f
C1343 VDPWR.t76 VGND 0.20169f
C1344 VDPWR.n1015 VGND 0.01108f
C1345 VDPWR.n1016 VGND 0.00791f
C1346 VDPWR.n1017 VGND 0.01146f
C1347 VDPWR.n1018 VGND 0.02504f
C1348 VDPWR.n1019 VGND 0.03243f
C1349 VDPWR.n1020 VGND 0.00405f
C1350 VDPWR.n1021 VGND 0.0325f
C1351 VDPWR.n1022 VGND 0.00754f
C1352 VDPWR.n1023 VGND 0.01021f
C1353 VDPWR.n1024 VGND 0.01007f
C1354 VDPWR.n1025 VGND 0.01021f
C1355 VDPWR.n1026 VGND 0.01007f
C1356 VDPWR.n1027 VGND 0.01021f
C1357 VDPWR.n1028 VGND 0.01007f
C1358 VDPWR.n1029 VGND 0.01007f
C1359 VDPWR.n1030 VGND 0.01021f
C1360 VDPWR.n1031 VGND 0.00944f
C1361 VDPWR.n1032 VGND 0.00958f
C1362 VDPWR.n1033 VGND 0.00944f
C1363 VDPWR.n1034 VGND 0.00958f
C1364 VDPWR.n1035 VGND 0.00944f
C1365 VDPWR.n1036 VGND 0.00944f
C1366 VDPWR.n1037 VGND 0.01731f
C1367 VDPWR.n1038 VGND 0.01049f
C1368 VDPWR.n1039 VGND 0.01049f
C1369 VDPWR.n1040 VGND 0.01049f
C1370 VDPWR.n1041 VGND 0.01088f
C1371 VDPWR.n1042 VGND 0.01112f
C1372 VDPWR.n1043 VGND 0.01112f
C1373 VDPWR.n1044 VGND 0.01112f
C1374 VDPWR.n1045 VGND 0.01112f
C1375 VDPWR.n1046 VGND 0.01119f
C1376 VDPWR.n1047 VGND 0.01021f
C1377 VDPWR.n1048 VGND 0.01049f
C1378 VDPWR.n1049 VGND 0.01049f
C1379 VDPWR.n1050 VGND 0.01049f
C1380 VDPWR.t52 VGND 0.03954f
C1381 VDPWR.n1051 VGND 0.07282f
C1382 VDPWR.n1052 VGND 0.12093f
C1383 VDPWR.n1053 VGND 0.00578f
C1384 VDPWR.n1054 VGND 0.00421f
C1385 VDPWR.n1055 VGND 0.00703f
C1386 VDPWR.n1056 VGND 0.00703f
C1387 VDPWR.n1057 VGND 0.00703f
C1388 VDPWR.n1058 VGND 0.02186f
C1389 VDPWR.n1059 VGND 0.00703f
C1390 VDPWR.n1060 VGND 0.02261f
C1391 VDPWR.n1061 VGND 0.01464f
C1392 VDPWR.n1062 VGND 0.00615f
C1393 VDPWR.n1063 VGND 0.00703f
C1394 VDPWR.n1064 VGND 0.0125f
C1395 VDPWR.n1065 VGND 0.00342f
C1396 VDPWR.n1066 VGND 0.01672f
C1397 VDPWR.n1067 VGND 0.02252f
C1398 VDPWR.n1068 VGND 0.00573f
C1399 VDPWR.n1069 VGND 0.06334f
C1400 VDPWR.n1070 VGND 0.01738f
C1401 VDPWR.t51 VGND 1.48465f
C1402 VDPWR.n1071 VGND 0.4482f
C1403 VDPWR.n1072 VGND 0.00184f
C1404 VDPWR.n1073 VGND 0.01492f
C1405 VDPWR.n1074 VGND 0.01335f
C1406 VDPWR.n1075 VGND 0.01038f
C1407 VDPWR.n1076 VGND 0.0063f
C1408 VDPWR.n1077 VGND 0.01255f
C1409 VDPWR.t68 VGND 0.21429f
C1410 VDPWR.n1078 VGND 0.00861f
C1411 VDPWR.n1079 VGND 0.0114f
C1412 VDPWR.n1080 VGND 0.01374f
C1413 VDPWR.n1081 VGND 0.01228f
C1414 VDPWR.n1082 VGND 0.01081f
C1415 VDPWR.n1083 VGND 0.00166f
C1416 VDPWR.n1084 VGND 0.00713f
C1417 VDPWR.n1085 VGND 0.00713f
C1418 VDPWR.n1086 VGND 0.00654f
C1419 VDPWR.n1087 VGND 0.00713f
C1420 VDPWR.n1088 VGND 0.00713f
C1421 VDPWR.n1089 VGND 0.00371f
C1422 VDPWR.n1090 VGND 0.00713f
C1423 VDPWR.n1091 VGND 0.00713f
C1424 VDPWR.n1092 VGND 0.0064f
C1425 VDPWR.n1093 VGND 0.02471f
C1426 VDPWR.n1094 VGND 0.02911f
C1427 VDPWR.n1095 VGND 0.01769f
C1428 VDPWR.n1096 VGND 0.02163f
C1429 VDPWR.n1097 VGND 0.01567f
C1430 VDPWR.n1098 VGND 0.02163f
C1431 VDPWR.n1099 VGND 0.01567f
C1432 VDPWR.n1100 VGND 0.02163f
C1433 VDPWR.n1101 VGND 0.01567f
C1434 VDPWR.n1102 VGND 0.02163f
C1435 VDPWR.n1103 VGND 0.01567f
C1436 VDPWR.n1104 VGND 0.02163f
C1437 VDPWR.n1105 VGND 0.01567f
C1438 VDPWR.n1106 VGND 0.02163f
C1439 VDPWR.n1107 VGND 0.01567f
C1440 VDPWR.n1108 VGND 0.02163f
C1441 VDPWR.n1109 VGND 0.01567f
C1442 VDPWR.n1110 VGND 0.02163f
C1443 VDPWR.n1111 VGND 0.01567f
C1444 VDPWR.n1112 VGND 0.02163f
C1445 VDPWR.n1113 VGND 0.01567f
C1446 VDPWR.n1114 VGND 0.02163f
C1447 VDPWR.n1115 VGND 0.01567f
C1448 VDPWR.n1116 VGND 0.02163f
C1449 VDPWR.n1117 VGND 0.01567f
C1450 VDPWR.n1118 VGND 0.02163f
C1451 VDPWR.n1119 VGND 0.01567f
C1452 VDPWR.n1120 VGND 0.02163f
C1453 VDPWR.n1121 VGND 0.01567f
C1454 VDPWR.n1122 VGND 0.02163f
C1455 VDPWR.n1123 VGND 0.01576f
C1456 VDPWR.n1124 VGND 0.04314f
C1457 VDPWR.n1125 VGND 0.03115f
C1458 VDPWR.n1126 VGND 0.04301f
C1459 VDPWR.n1127 VGND 0.03115f
C1460 VDPWR.n1128 VGND 0.04301f
C1461 VDPWR.n1129 VGND 0.03115f
C1462 VDPWR.n1130 VGND 0.04301f
C1463 VDPWR.n1131 VGND 0.03115f
C1464 VDPWR.n1132 VGND 0.04301f
C1465 VDPWR.n1133 VGND 0.03115f
C1466 VDPWR.n1134 VGND 0.04301f
C1467 VDPWR.n1135 VGND 0.03115f
C1468 VDPWR.n1136 VGND 0.04301f
C1469 VDPWR.n1137 VGND 0.03115f
C1470 VDPWR.n1138 VGND 0.04301f
C1471 VDPWR.n1139 VGND 0.03115f
C1472 VDPWR.n1140 VGND 0.04301f
C1473 VDPWR.n1141 VGND 0.03115f
C1474 VDPWR.n1142 VGND 0.04301f
C1475 VDPWR.n1143 VGND 0.03115f
C1476 VDPWR.n1144 VGND 0.04301f
C1477 VDPWR.n1145 VGND 0.03115f
C1478 VDPWR.n1146 VGND 0.04301f
C1479 VDPWR.n1147 VGND 0.03115f
C1480 VDPWR.n1148 VGND 0.04301f
C1481 VDPWR.n1149 VGND 0.03115f
C1482 VDPWR.n1150 VGND 0.04301f
C1483 VDPWR.n1151 VGND 0.03115f
C1484 VDPWR.n1152 VGND 0.02418f
C1485 VDPWR.n1153 VGND 0.07257f
C1486 VDPWR.n1154 VGND 1.73157f
C1487 VDPWR.n1155 VGND 2.41259f
C1488 VDPWR.n1156 VGND 1.82455f
C1489 VDPWR.n1157 VGND 1.32123f
C1490 VDPWR.n1158 VGND 0.04638f
C1491 VDPWR.n1159 VGND 0.02341f
C1492 VDPWR.n1160 VGND 0.03115f
C1493 VDPWR.n1161 VGND 0.04301f
C1494 VDPWR.n1162 VGND 0.04301f
C1495 VDPWR.n1163 VGND 0.04301f
C1496 VDPWR.n1164 VGND 0.03115f
C1497 VDPWR.n1165 VGND 0.03115f
C1498 VDPWR.n1166 VGND 0.03115f
C1499 VDPWR.n1167 VGND 0.04301f
C1500 VDPWR.n1168 VGND 0.04301f
C1501 VDPWR.n1169 VGND 0.04301f
C1502 VDPWR.n1170 VGND 0.03115f
C1503 VDPWR.n1171 VGND 0.03115f
C1504 VDPWR.n1172 VGND 0.03115f
C1505 VDPWR.n1173 VGND 0.04301f
C1506 VDPWR.n1174 VGND 0.04301f
C1507 VDPWR.n1175 VGND 0.04301f
C1508 VDPWR.n1176 VGND 0.03115f
C1509 VDPWR.n1177 VGND 0.03115f
C1510 VDPWR.n1178 VGND 0.03115f
C1511 VDPWR.n1179 VGND 0.04301f
C1512 VDPWR.n1180 VGND 0.04301f
C1513 VDPWR.n1181 VGND 0.04301f
C1514 VDPWR.n1182 VGND 0.03115f
C1515 VDPWR.n1183 VGND 0.03115f
C1516 VDPWR.n1184 VGND 0.03115f
C1517 VDPWR.n1185 VGND 0.04301f
C1518 VDPWR.n1186 VGND 0.04301f
C1519 VDPWR.n1187 VGND 0.04301f
C1520 VDPWR.n1188 VGND 0.03115f
C1521 VDPWR.n1189 VGND 0.03115f
C1522 VDPWR.n1190 VGND 0.03115f
C1523 VDPWR.n1191 VGND 0.04301f
C1524 VDPWR.n1192 VGND 0.04301f
C1525 VDPWR.n1193 VGND 0.04301f
C1526 VDPWR.n1194 VGND 0.03115f
C1527 VDPWR.n1195 VGND 0.03115f
C1528 VDPWR.n1196 VGND 0.03115f
C1529 VDPWR.n1197 VGND 0.04301f
C1530 VDPWR.n1198 VGND 0.04301f
C1531 VDPWR.n1199 VGND 0.04301f
C1532 VDPWR.n1200 VGND 0.03115f
C1533 VDPWR.n1201 VGND 0.03115f
C1534 VDPWR.n1202 VGND 0.03115f
C1535 VDPWR.n1203 VGND 0.04301f
C1536 VDPWR.n1204 VGND 0.04301f
C1537 VDPWR.n1205 VGND 0.04301f
C1538 VDPWR.n1206 VGND 0.03115f
C1539 VDPWR.n1207 VGND 0.03115f
C1540 VDPWR.n1208 VGND 0.03115f
C1541 VDPWR.n1209 VGND 0.04301f
C1542 VDPWR.n1210 VGND 0.04301f
C1543 VDPWR.n1211 VGND 0.04301f
C1544 VDPWR.n1212 VGND 0.03115f
C1545 VDPWR.n1213 VGND 0.03115f
C1546 VDPWR.n1214 VGND 0.03115f
C1547 VDPWR.n1215 VGND 0.04301f
C1548 VDPWR.n1216 VGND 0.04301f
C1549 VDPWR.n1217 VGND 0.04301f
C1550 VDPWR.n1218 VGND 0.03115f
C1551 VDPWR.n1219 VGND 0.03115f
C1552 VDPWR.n1220 VGND 0.03115f
C1553 VDPWR.n1221 VGND 0.04301f
C1554 VDPWR.n1222 VGND 0.04301f
C1555 VDPWR.n1223 VGND 0.04301f
C1556 VDPWR.n1224 VGND 0.03115f
C1557 VDPWR.n1225 VGND 0.03115f
C1558 VDPWR.n1226 VGND 0.03115f
C1559 VDPWR.n1227 VGND 0.04301f
C1560 VDPWR.n1228 VGND 0.04301f
C1561 VDPWR.n1229 VGND 0.04301f
C1562 VDPWR.n1230 VGND 0.03115f
C1563 VDPWR.n1231 VGND 0.03115f
C1564 VDPWR.n1232 VGND 0.03115f
C1565 VDPWR.n1233 VGND 0.04301f
C1566 VDPWR.n1234 VGND 0.04301f
C1567 VDPWR.n1235 VGND 0.04301f
C1568 VDPWR.n1236 VGND 0.03115f
C1569 VDPWR.n1237 VGND 0.03115f
C1570 VDPWR.n1238 VGND 0.03115f
C1571 VDPWR.n1239 VGND 0.04301f
C1572 VDPWR.n1240 VGND 0.04301f
C1573 VDPWR.n1241 VGND 0.04314f
C1574 VDPWR.n1242 VGND 0.03124f
C1575 VDPWR.n1243 VGND 0.03124f
C1576 VDPWR.n1244 VGND 0.03115f
C1577 VDPWR.n1245 VGND 0.04301f
C1578 VDPWR.n1246 VGND 0.02176f
C1579 VDPWR.n1247 VGND 0.02163f
C1580 VDPWR.n1248 VGND 0.01567f
C1581 VDPWR.n1249 VGND 0.01567f
C1582 VDPWR.n1250 VGND 0.01567f
C1583 VDPWR.n1251 VGND 0.02163f
C1584 VDPWR.n1252 VGND 0.02163f
C1585 VDPWR.n1253 VGND 0.02163f
C1586 VDPWR.n1254 VGND 0.01567f
C1587 VDPWR.n1255 VGND 0.01567f
C1588 VDPWR.n1256 VGND 0.01567f
C1589 VDPWR.n1257 VGND 0.02163f
C1590 VDPWR.n1258 VGND 0.02163f
C1591 VDPWR.n1259 VGND 0.02163f
C1592 VDPWR.n1260 VGND 0.01567f
C1593 VDPWR.n1261 VGND 0.01567f
C1594 VDPWR.n1262 VGND 0.01567f
C1595 VDPWR.n1263 VGND 0.02163f
C1596 VDPWR.n1264 VGND 0.02163f
C1597 VDPWR.n1265 VGND 0.02163f
C1598 VDPWR.n1266 VGND 0.01567f
C1599 VDPWR.n1267 VGND 0.01567f
C1600 VDPWR.n1268 VGND 0.01567f
C1601 VDPWR.n1269 VGND 0.02163f
C1602 VDPWR.n1270 VGND 0.02163f
C1603 VDPWR.n1271 VGND 0.02163f
C1604 VDPWR.n1272 VGND 0.01567f
C1605 VDPWR.n1273 VGND 0.01567f
C1606 VDPWR.n1274 VGND 0.01567f
C1607 VDPWR.n1275 VGND 0.02163f
C1608 VDPWR.n1276 VGND 0.02163f
C1609 VDPWR.n1277 VGND 0.02163f
C1610 VDPWR.n1278 VGND 0.01567f
C1611 VDPWR.n1279 VGND 0.01567f
C1612 VDPWR.n1280 VGND 0.01567f
C1613 VDPWR.n1281 VGND 0.02163f
C1614 VDPWR.n1282 VGND 0.02163f
C1615 VDPWR.n1283 VGND 0.02163f
C1616 VDPWR.n1284 VGND 0.01567f
C1617 VDPWR.n1285 VGND 0.01567f
C1618 VDPWR.n1286 VGND 0.01567f
C1619 VDPWR.n1287 VGND 0.02163f
C1620 VDPWR.n1288 VGND 0.02163f
C1621 VDPWR.n1289 VGND 0.02163f
C1622 VDPWR.n1290 VGND 0.01567f
C1623 VDPWR.n1291 VGND 0.01567f
C1624 VDPWR.n1292 VGND 0.01567f
C1625 VDPWR.n1293 VGND 0.02163f
C1626 VDPWR.n1294 VGND 0.02163f
C1627 VDPWR.n1295 VGND 0.02163f
C1628 VDPWR.n1296 VGND 0.01567f
C1629 VDPWR.n1297 VGND 0.01567f
C1630 VDPWR.n1298 VGND 0.01567f
C1631 VDPWR.n1299 VGND 0.02163f
C1632 VDPWR.n1300 VGND 0.02163f
C1633 VDPWR.n1301 VGND 0.02163f
C1634 VDPWR.n1302 VGND 0.01567f
C1635 VDPWR.n1303 VGND 0.01567f
C1636 VDPWR.n1304 VGND 0.01567f
C1637 VDPWR.n1305 VGND 0.02163f
C1638 VDPWR.n1306 VGND 0.02163f
C1639 VDPWR.n1307 VGND 0.02163f
C1640 VDPWR.n1308 VGND 0.01567f
C1641 VDPWR.n1309 VGND 0.01567f
C1642 VDPWR.n1310 VGND 0.01567f
C1643 VDPWR.n1311 VGND 0.02163f
C1644 VDPWR.n1312 VGND 0.02163f
C1645 VDPWR.n1313 VGND 0.02163f
C1646 VDPWR.n1314 VGND 0.01567f
C1647 VDPWR.n1315 VGND 0.01567f
C1648 VDPWR.n1316 VGND 0.01567f
C1649 VDPWR.n1317 VGND 0.02163f
C1650 VDPWR.n1318 VGND 0.02163f
C1651 VDPWR.n1319 VGND 0.02163f
C1652 VDPWR.n1320 VGND 0.01567f
C1653 VDPWR.n1321 VGND 0.01567f
C1654 VDPWR.n1322 VGND 0.01567f
C1655 VDPWR.n1323 VGND 0.02163f
C1656 VDPWR.n1324 VGND 0.02163f
C1657 VDPWR.n1325 VGND 0.02163f
C1658 VDPWR.n1326 VGND 0.01567f
C1659 VDPWR.n1327 VGND 0.01567f
C1660 VDPWR.n1328 VGND 0.00811f
C1661 VDPWR.n1329 VGND 0.00305f
C1662 VDPWR.n1330 VGND 0.50309f
C1663 VDPWR.n1331 VGND 0.04327f
C1664 VDPWR.n1332 VGND 0.0469f
C1665 VDPWR.n1333 VGND 0.01169f
C1666 VDPWR.n1334 VGND 0.00713f
C1667 VDPWR.n1335 VGND 0.00713f
C1668 VDPWR.n1336 VGND 0.00449f
C1669 VDPWR.n1337 VGND 0.00722f
C1670 VDPWR.n1338 VGND 0.00703f
C1671 VDPWR.n1339 VGND 0.00722f
C1672 VDPWR.n1340 VGND 0.00713f
C1673 VDPWR.n1341 VGND 0.01013f
C1674 VDPWR.n1342 VGND 0.00654f
C1675 VDPWR.n1343 VGND 0.00557f
C1676 VDPWR.n1344 VGND 0.00186f
C1677 VDPWR.n1345 VGND 0.01345f
C1678 VDPWR.n1346 VGND 0.0147f
C1679 VDPWR.n1347 VGND 0.0469f
C1680 VDPWR.n1348 VGND 0.04327f
C1681 VDPWR.n1349 VGND 0.01865f
C1682 VDPWR.n1350 VGND 0.01622f
C1683 VDPWR.n1351 VGND 0.04327f
C1684 VDPWR.n1352 VGND 0.0469f
C1685 VDPWR.n1353 VGND 0.00713f
C1686 VDPWR.n1354 VGND 0.00703f
C1687 VDPWR.n1355 VGND 0.00703f
C1688 VDPWR.n1356 VGND 0.00703f
C1689 VDPWR.t64 VGND 0.2313f
C1690 VDPWR.n1357 VGND 0.00703f
C1691 VDPWR.n1358 VGND 0.00703f
C1692 VDPWR.n1359 VGND 0.0114f
C1693 VDPWR.n1360 VGND 0.00644f
C1694 VDPWR.n1361 VGND 0.0075f
C1695 VDPWR.n1362 VGND 0.00586f
C1696 VDPWR.n1363 VGND 0.01218f
C1697 VDPWR.n1364 VGND 0.02151f
C1698 VDPWR.n1365 VGND 0.03133f
C1699 VDPWR.n1366 VGND 0.04327f
C1700 VDPWR.n1367 VGND 0.01981f
C1701 VDPWR.n1368 VGND 0.04327f
C1702 VDPWR.n1369 VGND 0.0224f
C1703 VDPWR.n1370 VGND 0.0469f
C1704 VDPWR.n1371 VGND 0.01218f
C1705 VDPWR.n1372 VGND 0.00713f
C1706 VDPWR.n1373 VGND 0
C1707 VDPWR.n1374 VGND 0.00713f
C1708 VDPWR.n1375 VGND 0.01377f
C1709 VDPWR.n1376 VGND 0.00713f
C1710 VDPWR.n1377 VGND 0.00713f
C1711 VDPWR.n1378 VGND 0.01443f
C1712 VDPWR.n1379 VGND 0.00508f
C1713 VDPWR.n1380 VGND 0.00478f
C1714 VDPWR.n1381 VGND 0.01365f
C1715 VDPWR.n1382 VGND 0.01751f
C1716 VDPWR.n1383 VGND 0.0469f
C1717 VDPWR.n1384 VGND 0.01825f
C1718 VDPWR.n1385 VGND 0.0469f
C1719 VDPWR.n1386 VGND 0.01797f
C1720 VDPWR.n1387 VGND 0.04327f
C1721 VDPWR.n1388 VGND 0.04327f
C1722 VDPWR.n1389 VGND 0.04327f
C1723 VDPWR.n1390 VGND 0.03133f
C1724 VDPWR.n1391 VGND 0.03133f
C1725 VDPWR.n1392 VGND 0.03133f
C1726 VDPWR.n1393 VGND 0.04327f
C1727 VDPWR.n1394 VGND 0.04327f
C1728 VDPWR.n1395 VGND 0.04327f
C1729 VDPWR.n1396 VGND 0.02589f
C1730 VDPWR.n1397 VGND 0.0469f
C1731 VDPWR.n1398 VGND 0.01797f
C1732 VDPWR.n1399 VGND 0.0469f
C1733 VDPWR.n1400 VGND 0.01825f
C1734 VDPWR.n1401 VGND 0.04327f
C1735 VDPWR.n1402 VGND 0.04327f
C1736 VDPWR.n1403 VGND 0.04327f
C1737 VDPWR.n1404 VGND 0.05131f
C1738 VDPWR.n1405 VGND 0.02297f
C1739 VDPWR.n1406 VGND 0.0469f
C1740 VDPWR.n1407 VGND 0.0176f
C1741 VDPWR.n1408 VGND 0.04327f
C1742 VDPWR.n1409 VGND 0.04327f
C1743 VDPWR.n1410 VGND 0.01815f
C1744 VDPWR.n1411 VGND 0.0469f
C1745 VDPWR.n1412 VGND 0.01806f
C1746 VDPWR.n1413 VGND 0.0469f
C1747 VDPWR.n1414 VGND 0.01815f
C1748 VDPWR.n1415 VGND 0.04327f
C1749 VDPWR.n1416 VGND 0.04327f
C1750 VDPWR.n1417 VGND 0.46257f
C1751 VDPWR.n1418 VGND 0.01622f
C1752 VDPWR.n1419 VGND 0.14246f
C1753 VDPWR.n1420 VGND 0.15987f
C1754 VDPWR.n1421 VGND 0.0668f
C1755 VDPWR.n1422 VGND 0.06699f
C1756 VDPWR.n1423 VGND 0.06745f
C1757 VDPWR.n1424 VGND 0.06745f
C1758 VDPWR.n1425 VGND 0.06763f
C1759 VDPWR.n1426 VGND 0.06745f
C1760 VDPWR.n1427 VGND 0.13112f
C1761 VDPWR.n1428 VGND 0.0389f
C1762 VDPWR.n1429 VGND 0.04656f
C1763 VDPWR.t0 VGND 10.1705f
C1764 VDPWR.n1430 VGND 0.72603f
C1765 VDPWR.n1431 VGND 0.00517f
C1766 VDPWR.n1432 VGND 0.00945f
C1767 VDPWR.n1433 VGND 0.0469f
C1768 VDPWR.n1434 VGND 0.01806f
C1769 VDPWR.n1435 VGND 0.04327f
C1770 VDPWR.n1436 VGND 0.04327f
C1771 VDPWR.n1437 VGND 0.04327f
C1772 VDPWR.n1438 VGND 0.02156f
C1773 VDPWR.n1439 VGND 0.0469f
C1774 VDPWR.n1440 VGND 0.02341f
C1775 VDPWR.n1441 VGND 0.0469f
C1776 VDPWR.n1442 VGND 0.01769f
C1777 VDPWR.n1443 VGND 0.04327f
C1778 VDPWR.n1444 VGND 0.04327f
C1779 VDPWR.n1445 VGND 0.04327f
C1780 VDPWR.n1446 VGND 0.03133f
C1781 VDPWR.n1447 VGND 0.03133f
C1782 VDPWR.n1448 VGND 0.03041f
C1783 VDPWR.n1449 VGND 0.04327f
C1784 VDPWR.n1450 VGND 0.04327f
C1785 VDPWR.n1451 VGND 0.01659f
C1786 VDPWR.n1452 VGND 0.01935f
C1787 VDPWR.n1453 VGND 0.0562f
C1788 VDPWR.n1454 VGND 0.01797f
C1789 VDPWR.n1455 VGND 0.04327f
C1790 VDPWR.n1456 VGND 0.04327f
C1791 VDPWR.n1457 VGND 0.02534f
C1792 VDPWR.n1458 VGND 0.02792f
C1793 VDPWR.n1459 VGND 0.05611f
C1794 VDPWR.n1460 VGND 0.01705f
C1795 VDPWR.n1461 VGND 0.04327f
C1796 VDPWR.n1462 VGND 0.09659f
C1797 VDPWR.n1463 VGND 0.0563f
C1798 VDPWR.n1464 VGND 0.87173f
C1799 VDPWR.n1465 VGND 1.21227f
C1800 VDPWR.n1466 VGND 0.02431f
C1801 VDPWR.n1467 VGND 0.04449f
C1802 VDPWR.n1468 VGND 0.04449f
C1803 VDPWR.n1469 VGND 0.04301f
C1804 VDPWR.n1470 VGND 0.04301f
C1805 VDPWR.n1471 VGND 0.04449f
C1806 VDPWR.n1472 VGND 0.04449f
C1807 VDPWR.n1473 VGND 0.04301f
C1808 VDPWR.n1474 VGND 0.04301f
C1809 VDPWR.n1475 VGND 0.04449f
C1810 VDPWR.n1476 VGND 0.04449f
C1811 VDPWR.n1477 VGND 0.04301f
C1812 VDPWR.n1478 VGND 0.04301f
C1813 VDPWR.n1479 VGND 0.04449f
C1814 VDPWR.n1480 VGND 0.04449f
C1815 VDPWR.n1481 VGND 0.04301f
C1816 VDPWR.n1482 VGND 0.04301f
C1817 VDPWR.n1483 VGND 0.04449f
C1818 VDPWR.n1484 VGND 0.04449f
C1819 VDPWR.n1485 VGND 0.04301f
C1820 VDPWR.n1486 VGND 0.04301f
C1821 VDPWR.n1487 VGND 0.04449f
C1822 VDPWR.n1488 VGND 0.04449f
C1823 VDPWR.n1489 VGND 0.04301f
C1824 VDPWR.n1490 VGND 0.04301f
C1825 VDPWR.n1491 VGND 0.04436f
C1826 VDPWR.n1492 VGND 0.04449f
C1827 VDPWR.n1493 VGND 0.04301f
C1828 VDPWR.n1494 VGND 0.04314f
C1829 VDPWR.n1495 VGND 0.04449f
C1830 VDPWR.n1496 VGND 0.04449f
C1831 VDPWR.n1497 VGND 0.04301f
C1832 VDPWR.n1498 VGND 0.04301f
C1833 VDPWR.n1499 VGND 0.04449f
C1834 VDPWR.n1500 VGND 0.04449f
C1835 VDPWR.n1501 VGND 0.04301f
C1836 VDPWR.n1502 VGND 0.04301f
C1837 VDPWR.n1503 VGND 0.04449f
C1838 VDPWR.n1504 VGND 0.04449f
C1839 VDPWR.n1505 VGND 0.04301f
C1840 VDPWR.n1506 VGND 0.04301f
C1841 VDPWR.n1507 VGND 0.04449f
C1842 VDPWR.n1508 VGND 0.04449f
C1843 VDPWR.n1509 VGND 0.04301f
C1844 VDPWR.n1510 VGND 0.04301f
C1845 VDPWR.n1511 VGND 0.04449f
C1846 VDPWR.n1512 VGND 0.04449f
C1847 VDPWR.n1513 VGND 0.04301f
C1848 VDPWR.n1514 VGND 0.04301f
C1849 VDPWR.n1515 VGND 0.04449f
C1850 VDPWR.n1516 VGND 0.04449f
C1851 VDPWR.n1517 VGND 0.04301f
C1852 VDPWR.n1518 VGND 0.04301f
C1853 VDPWR.n1519 VGND 0.04449f
C1854 VDPWR.n1520 VGND 0.04449f
C1855 VDPWR.n1521 VGND 0.04301f
C1856 VDPWR.n1522 VGND 0.04301f
C1857 VDPWR.n1523 VGND 0.04449f
C1858 VDPWR.n1524 VGND 0.04449f
C1859 VDPWR.n1525 VGND 0.04301f
C1860 VDPWR.n1526 VGND 0.04301f
C1861 VDPWR.n1527 VGND 0.04449f
C1862 VDPWR.n1528 VGND 0.04449f
C1863 VDPWR.n1529 VGND 0.04301f
C1864 VDPWR.n1530 VGND 0.04301f
C1865 VDPWR.n1531 VGND 0.04449f
C1866 VDPWR.n1532 VGND 0.04449f
C1867 VDPWR.n1533 VGND 0.04301f
C1868 VDPWR.n1534 VGND 0.04301f
C1869 VDPWR.n1535 VGND 0.04449f
C1870 VDPWR.n1536 VGND 0.04449f
C1871 VDPWR.n1537 VGND 0.04301f
C1872 VDPWR.n1538 VGND 0.04301f
C1873 VDPWR.n1539 VGND 0.04449f
C1874 VDPWR.n1540 VGND 0.04449f
C1875 VDPWR.n1541 VGND 0.04463f
C1876 VDPWR.n1542 VGND 0.04314f
C1877 VDPWR.n1543 VGND 0.04466f
C1878 VDPWR.n1544 VGND 0.10515f
C1879 VDPWR.n1545 VGND 0.02328f
C1880 VDPWR.n1546 VGND 0.10515f
C1881 VDPWR.n1547 VGND 0.10515f
C1882 VDPWR.n1548 VGND 0.9077f
.ends
